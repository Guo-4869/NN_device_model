// ============================================================
// BSIM-NN v6: SPICE-Compatible Neural Network MOSFET Model
// 3 inputs -> 32 tanh -> 32 tanh -> 1 output (log10 ID)
// ============================================================
// SPICE convergence features:
//  - Smooth tanh-based input clamping (no if/ternary)
//  - Minimum std 0.05 to avoid division by zero
//  - Gate/body conductance paths for Jacobian stability
//  - Weight-regularized to avoid tanh saturation
//  - Smooth VDS->0 transition
// ============================================================

`include "disciplines.vams"
`include "constants.vams"

module bsim_nn_v6(d, g, s, b);
    inout d, g, s, b; electrical d, g, s, b;

    parameter real L = 1e-6 from (0:inf);
    parameter real W = 10e-6 from (0:inf);

    real VGS, VDS, VBS, VGS_n, VDS_n, VBS_n;
    real h1_0, h1_1, h1_2, h1_3, h1_4, h1_5, h1_6, h1_7, h1_8, h1_9, h1_10, h1_11, h1_12, h1_13, h1_14, h1_15, h1_16, h1_17, h1_18, h1_19, h1_20, h1_21, h1_22, h1_23, h1_24, h1_25, h1_26, h1_27, h1_28, h1_29, h1_30, h1_31;
    real h2_0, h2_1, h2_2, h2_3, h2_4, h2_5, h2_6, h2_7, h2_8, h2_9, h2_10, h2_11, h2_12, h2_13, h2_14, h2_15, h2_16, h2_17, h2_18, h2_19, h2_20, h2_21, h2_22, h2_23, h2_24, h2_25, h2_26, h2_27, h2_28, h2_29, h2_30, h2_31;
    real log10_Id, Ids, vds_smooth;

    real mean_vgs = 0.50000000;
    real std_vgs  = 0.41231056;
    real mean_vds = 0.60050000;
    real std_vds  = 0.35311455;
    real mean_vbs = -0.25000000;
    real std_vbs  = 0.17677670;
    analog begin
        VGS = V(g, s); VDS = V(d, s); VBS = V(b, s);

        // Smooth clamp to training range via tanh
        VGS = 0.5 + 0.7 * tanh((VGS - 0.5) / 0.7);
        VDS = 0.6 + 0.6 * tanh((VDS - 0.6) / 0.6);
        VBS = -0.25 + 0.25 * tanh((VBS + 0.25) / 0.25);

        VGS_n = (VGS - mean_vgs) / std_vgs;
        VDS_n = (VDS - mean_vds) / std_vds;
        VBS_n = (VBS - mean_vbs) / std_vbs;

        // Hidden Layer 1 (tanh)

        h1_0 = tanh(0.81865501 + 0.09748114*VGS_n + 0.44684786*VDS_n + -0.01731172*VBS_n);
        h1_1 = tanh(-0.12429383 + -0.48148665*VGS_n + 0.08678323*VDS_n + -0.02731940*VBS_n);
        h1_2 = tanh(0.72455782 + -0.58097619*VGS_n + 0.74216962*VDS_n + 0.00358337*VBS_n);
        h1_3 = tanh(0.36522344 + 0.71445709*VGS_n + 0.24028318*VDS_n + 0.05798057*VBS_n);
        h1_4 = tanh(0.08222080 + -0.36447200*VGS_n + -0.16113190*VDS_n + -0.16986944*VBS_n);
        h1_5 = tanh(-0.66938180 + -0.11242769*VGS_n + -0.22287595*VDS_n + 0.01727545*VBS_n);
        h1_6 = tanh(0.49215159 + 0.17397930*VGS_n + -0.40469843*VDS_n + 0.00710444*VBS_n);
        h1_7 = tanh(0.53034264 + 0.22497234*VGS_n + 0.06162276*VDS_n + 0.01323365*VBS_n);
        h1_8 = tanh(0.46076342 + 0.16696812*VGS_n + 0.04657763*VDS_n + -0.11944740*VBS_n);
        h1_9 = tanh(0.28563595 + 0.53691655*VGS_n + 0.04958789*VDS_n + 0.02850047*VBS_n);
        h1_10 = tanh(0.76688898 + 0.12526709*VGS_n + 0.39336687*VDS_n + 0.00420315*VBS_n);
        h1_11 = tanh(1.17790794 + -0.26192784*VGS_n + 0.83246982*VDS_n + -0.03583493*VBS_n);
        h1_12 = tanh(0.99678987 + 0.07882898*VGS_n + 0.57477403*VDS_n + 0.01700754*VBS_n);
        h1_13 = tanh(0.63762027 + 0.13762511*VGS_n + 0.17785911*VDS_n + 0.01291894*VBS_n);
        h1_14 = tanh(0.08302242 + -0.43053317*VGS_n + 0.07825942*VDS_n + 0.14105839*VBS_n);
        h1_15 = tanh(0.53568590 + 0.05502122*VGS_n + 0.20398788*VDS_n + 0.26348206*VBS_n);
        h1_16 = tanh(-1.29268909 + 2.73802829*VGS_n + -0.29522607*VDS_n + 0.19158366*VBS_n);
        h1_17 = tanh(-0.93101025 + 0.03280389*VGS_n + -0.55293655*VDS_n + 0.01606168*VBS_n);
        h1_18 = tanh(0.50733215 + 0.28206366*VGS_n + -0.30792981*VDS_n + 0.02325803*VBS_n);
        h1_19 = tanh(0.10629683 + -0.38034689*VGS_n + 0.07109158*VDS_n + 0.10778874*VBS_n);
        h1_20 = tanh(-1.31253707 + 2.71447134*VGS_n + 0.43623948*VDS_n + 0.17758285*VBS_n);
        h1_21 = tanh(-0.20495805 + -0.44660217*VGS_n + 0.02938818*VDS_n + -0.07424291*VBS_n);
        h1_22 = tanh(-0.71247607 + -0.34234980*VGS_n + -0.43699571*VDS_n + -0.06294148*VBS_n);
        h1_23 = tanh(0.04235827 + 0.44146097*VGS_n + -0.08852752*VDS_n + 0.13310817*VBS_n);
        h1_24 = tanh(1.10117495 + -0.25910577*VGS_n + 0.71053988*VDS_n + -0.02294795*VBS_n);
        h1_25 = tanh(0.47534171 + 0.60813487*VGS_n + -0.08644217*VDS_n + 0.04886860*VBS_n);
        h1_26 = tanh(-0.28035963 + 0.40966699*VGS_n + -0.86389315*VDS_n + 0.03606391*VBS_n);
        h1_27 = tanh(-0.26130873 + 0.06422785*VGS_n + 0.07432830*VDS_n + -0.03595329*VBS_n);
        h1_28 = tanh(-0.53534555 + -0.13976987*VGS_n + 0.11820503*VDS_n + 0.01913071*VBS_n);
        h1_29 = tanh(0.09885564 + -0.34996268*VGS_n + -0.10212435*VDS_n + 0.07977235*VBS_n);
        h1_30 = tanh(0.08035466 + -0.74580950*VGS_n + -0.14467174*VDS_n + -0.10660024*VBS_n);
        h1_31 = tanh(-0.57611883 + -0.10545437*VGS_n + -0.24312674*VDS_n + 0.09976488*VBS_n);

        // Hidden Layer 2 (tanh)

        h2_0 = tanh(0.09662981 + -0.77424806*h1_0 + 0.19459563*h1_1 + -0.52385849*h1_2 + -0.74117434*h1_3 + -0.01393102*h1_4 + 0.03056891*h1_5 + 0.04991976*h1_6 + -0.13759942*h1_7 + 0.07511244*h1_8 + -0.29463002*h1_9 + -0.50896668*h1_10 + -1.01521945*h1_11 + -1.41156602*h1_12 + -0.13423081*h1_13 + 0.15964989*h1_14 + -0.26331556*h1_15 + 0.75020182*h1_16 + 1.67884684*h1_17 + 0.08294946*h1_18 + 0.11161068*h1_19 + 0.42526135*h1_20 + 0.05436422*h1_21 + 1.17671871*h1_22 + 0.25374207*h1_23 + -1.45683706*h1_24 + -0.39005518*h1_25 + -0.50666070*h1_26 + -0.12627971*h1_27 + -0.23004112*h1_28 + 0.02192578*h1_29 + -0.00934837*h1_30 + 0.15726408*h1_31);
        h2_1 = tanh(0.20676477 + 0.02346925*h1_0 + -0.41487959*h1_1 + 0.19867398*h1_2 + 0.17392392*h1_3 + -0.11604800*h1_4 + -0.16173826*h1_5 + 0.31998339*h1_6 + 0.38867515*h1_7 + 0.17131190*h1_8 + 0.57471555*h1_9 + 0.21358621*h1_10 + 0.02707336*h1_11 + 0.28061587*h1_12 + 0.30336523*h1_13 + -0.19770680*h1_14 + -0.03851996*h1_15 + 0.03554656*h1_16 + -0.45080394*h1_17 + 0.58772039*h1_18 + -0.01985267*h1_19 + -0.04118299*h1_20 + -0.68745655*h1_21 + -0.49805892*h1_22 + 0.37399185*h1_23 + 1.12694824*h1_24 + 0.69975364*h1_25 + 0.77830881*h1_26 + -0.17827648*h1_27 + -0.53338391*h1_28 + -0.04055333*h1_29 + -0.18325342*h1_30 + 0.15886079*h1_31);
        h2_2 = tanh(-0.78783882 + -1.81339276*h1_0 + 0.34511453*h1_1 + 0.22978917*h1_2 + 0.29521710*h1_3 + -0.49064881*h1_4 + 1.28453350*h1_5 + -0.79320663*h1_6 + -0.86793715*h1_7 + -0.78117245*h1_8 + -0.47721711*h1_9 + -1.24197388*h1_10 + -0.43557987*h1_11 + -1.47723186*h1_12 + -1.18171442*h1_13 + -0.10347713*h1_14 + -0.52486873*h1_15 + -0.14347561*h1_16 + 1.38240945*h1_17 + -0.75471205*h1_18 + -0.05935040*h1_19 + 0.29285017*h1_20 + 0.12758683*h1_21 + 0.32853156*h1_22 + -0.25338620*h1_23 + -0.19209668*h1_24 + -0.43509355*h1_25 + -0.11976597*h1_26 + 0.42824513*h1_27 + 0.72263265*h1_28 + -0.26380447*h1_29 + -0.16666813*h1_30 + 0.78476876*h1_31);
        h2_3 = tanh(-0.06356920 + 0.02942046*h1_0 + -0.28487059*h1_1 + 0.12254920*h1_2 + 0.50229496*h1_3 + -0.20546414*h1_4 + -0.02059009*h1_5 + 0.04441839*h1_6 + -0.09818754*h1_7 + -0.04637643*h1_8 + 0.34369531*h1_9 + 0.11488603*h1_10 + 0.11370276*h1_11 + 0.18390708*h1_12 + 0.04262248*h1_13 + -0.27515778*h1_14 + -0.00990523*h1_15 + -0.24201173*h1_16 + -0.30031958*h1_17 + 0.17759879*h1_18 + -0.07771397*h1_19 + 0.14732216*h1_20 + -0.20467913*h1_21 + -0.36121556*h1_22 + 0.14154994*h1_23 + 0.90809518*h1_24 + 0.35903257*h1_25 + 0.52132624*h1_26 + 0.23339309*h1_27 + 0.14816400*h1_28 + -0.24721535*h1_29 + -0.32145387*h1_30 + -0.03876708*h1_31);
        h2_4 = tanh(-0.69146448 + -2.70026278*h1_0 + 0.36165810*h1_1 + 0.00512460*h1_2 + -0.32074469*h1_3 + -0.28650582*h1_4 + 1.27989030*h1_5 + -0.42639270*h1_6 + -1.34320748*h1_7 + -0.85825855*h1_8 + -0.48150024*h1_9 + -1.94289708*h1_10 + -0.39717677*h1_11 + -1.66612160*h1_12 + -1.26509500*h1_13 + -0.15082438*h1_14 + -0.73154050*h1_15 + -0.11209284*h1_16 + 1.91604340*h1_17 + -0.85391939*h1_18 + -0.11386688*h1_19 + 0.32628867*h1_20 + 0.53745133*h1_21 + 0.71208823*h1_22 + -0.44525418*h1_23 + -0.19603273*h1_24 + -0.46926057*h1_25 + -0.17110258*h1_26 + 0.64897430*h1_27 + 0.91665685*h1_28 + -0.07783075*h1_29 + 0.07398251*h1_30 + 1.05488038*h1_31);
        h2_5 = tanh(0.29350597 + 0.36627030*h1_0 + -0.18205126*h1_1 + 0.09944812*h1_2 + -0.58501035*h1_3 + 0.13972567*h1_4 + -0.21805210*h1_5 + -0.03887427*h1_6 + 0.24658616*h1_7 + 0.35197830*h1_8 + -0.30667982*h1_9 + 0.14185114*h1_10 + -0.15751667*h1_11 + 0.08234517*h1_12 + 0.29215446*h1_13 + 0.20359990*h1_14 + 0.18698551*h1_15 + 0.47564125*h1_16 + -0.12962575*h1_17 + -0.01556779*h1_18 + -0.01618434*h1_19 + 0.08115763*h1_20 + -0.04080899*h1_21 + -0.05562704*h1_22 + -0.17376406*h1_23 + -0.37220919*h1_24 + -0.40295562*h1_25 + 0.14629014*h1_26 + 0.01723378*h1_27 + -0.26724994*h1_28 + 0.10099722*h1_29 + -0.13236526*h1_30 + -0.08842272*h1_31);
        h2_6 = tanh(0.59812927 + 2.28422713*h1_0 + -0.13600153*h1_1 + 0.05831929*h1_2 + 0.12030925*h1_3 + 0.00255057*h1_4 + -1.15264189*h1_5 + 0.65209395*h1_6 + 1.23766613*h1_7 + 0.84319139*h1_8 + 0.39956766*h1_9 + 1.80104721*h1_10 + 0.62220234*h1_11 + 2.09623218*h1_12 + 1.44390082*h1_13 + -0.05694460*h1_14 + 0.81208485*h1_15 + -0.08695301*h1_16 + -1.65115643*h1_17 + 0.84517950*h1_18 + 0.04780975*h1_19 + -0.47103593*h1_20 + -0.43487796*h1_21 + -0.85073197*h1_22 + 0.18162075*h1_23 + 0.18462470*h1_24 + 0.64106560*h1_25 + -0.00381967*h1_26 + -0.49156344*h1_27 + -0.67162120*h1_28 + -0.07988804*h1_29 + -0.20198421*h1_30 + -0.88382614*h1_31);
        h2_7 = tanh(-0.00684269 + 0.02179819*h1_0 + -0.33514297*h1_1 + -0.15790850*h1_2 + 0.29164729*h1_3 + 0.11284850*h1_4 + 0.02484965*h1_5 + 0.37730160*h1_6 + 0.17351712*h1_7 + 0.13235056*h1_8 + 0.43370304*h1_9 + 0.14780524*h1_10 + -0.18169554*h1_11 + -0.06810553*h1_12 + 0.00718229*h1_13 + -0.11374487*h1_14 + 0.10810014*h1_15 + 0.21764290*h1_16 + -0.02229883*h1_17 + 0.37038994*h1_18 + -0.20228586*h1_19 + -0.01457964*h1_20 + -0.51225823*h1_21 + -0.32829770*h1_22 + 0.14954741*h1_23 + 0.81128770*h1_24 + 0.64722490*h1_25 + 0.35869080*h1_26 + -0.05539090*h1_27 + -0.18469080*h1_28 + -0.10762030*h1_29 + -0.15372901*h1_30 + -0.09934233*h1_31);
        h2_8 = tanh(-0.72529662 + -0.60598946*h1_0 + 0.07155799*h1_1 + 0.11958703*h1_2 + 0.32171351*h1_3 + -0.45903802*h1_4 + 0.79650849*h1_5 + -0.56841087*h1_6 + -0.90474468*h1_7 + -0.67744130*h1_8 + -0.04348354*h1_9 + -0.62124217*h1_10 + -0.30395359*h1_11 + -0.42344046*h1_12 + -0.86812758*h1_13 + -0.13369833*h1_14 + -0.41163656*h1_15 + -0.07048266*h1_16 + 0.42104164*h1_17 + -0.67319244*h1_18 + -0.07965321*h1_19 + 0.20345819*h1_20 + -0.07370990*h1_21 + 0.17521098*h1_22 + 0.05991816*h1_23 + -0.01079701*h1_24 + 0.15393867*h1_25 + -0.48207805*h1_26 + 0.48322999*h1_27 + 0.66404682*h1_28 + -0.40515512*h1_29 + 0.02128190*h1_30 + 0.50870305*h1_31);
        h2_9 = tanh(-0.94327217 + -1.03042960*h1_0 + -0.14461702*h1_1 + -0.10643821*h1_2 + 0.20622885*h1_3 + -0.33213189*h1_4 + 0.92481315*h1_5 + -0.67571127*h1_6 + -0.99515986*h1_7 + -0.81327808*h1_8 + -0.16986011*h1_9 + -0.83520555*h1_10 + -0.51491582*h1_11 + -0.90344441*h1_12 + -0.81937605*h1_13 + -0.43273512*h1_14 + -0.62017763*h1_15 + -0.03707964*h1_16 + 1.09152031*h1_17 + -0.96894115*h1_18 + -0.39573318*h1_19 + 0.26786667*h1_20 + 0.25171545*h1_21 + 0.39228910*h1_22 + 0.25454515*h1_23 + -0.15653805*h1_24 + -0.06982252*h1_25 + -0.80585641*h1_26 + 0.81006199*h1_27 + 1.04979968*h1_28 + -0.27749225*h1_29 + -0.36327451*h1_30 + 0.83483779*h1_31);
        h2_10 = tanh(0.06947326 + -0.03688698*h1_0 + 0.08103526*h1_1 + -0.19129416*h1_2 + -0.70922953*h1_3 + 0.20348741*h1_4 + 0.15779692*h1_5 + 0.11048887*h1_6 + -0.02575361*h1_7 + 0.10786725*h1_8 + -0.44568822*h1_9 + -0.04565363*h1_10 + -0.10104660*h1_11 + -0.13808565*h1_12 + 0.11733446*h1_13 + 0.03258477*h1_14 + 0.21606819*h1_15 + -0.31161472*h1_16 + 0.25182354*h1_17 + -0.19976820*h1_18 + 0.15719682*h1_19 + -0.59387523*h1_20 + 0.44854566*h1_21 + 0.18415740*h1_22 + 0.16519769*h1_23 + -0.67620814*h1_24 + -0.25602812*h1_25 + -0.42190766*h1_26 + -0.14964893*h1_27 + -0.05589923*h1_28 + 0.33663556*h1_29 + 0.50402492*h1_30 + -0.16837949*h1_31);
        h2_11 = tanh(0.02429640 + -0.05934178*h1_0 + 0.26960361*h1_1 + 0.23241787*h1_2 + -0.56915236*h1_3 + 0.05416277*h1_4 + -0.03591403*h1_5 + -0.04334883*h1_6 + -0.25660476*h1_7 + 0.06953996*h1_8 + -0.35449970*h1_9 + 0.03582100*h1_10 + 0.04938220*h1_11 + -0.17766532*h1_12 + 0.11577827*h1_13 + 0.19171867*h1_14 + 0.07227480*h1_15 + -0.58120865*h1_16 + 0.32988101*h1_17 + -0.13440672*h1_18 + 0.30195460*h1_19 + -0.21494639*h1_20 + 0.21303326*h1_21 + 0.36652979*h1_22 + -0.34385028*h1_23 + -0.23316559*h1_24 + -0.78120333*h1_25 + -0.48900133*h1_26 + 0.08264173*h1_27 + 0.29946285*h1_28 + 0.10872367*h1_29 + 0.28745416*h1_30 + 0.07746994*h1_31);
        h2_12 = tanh(-0.09992673 + -0.07173953*h1_0 + 0.18278022*h1_1 + -0.15711500*h1_2 + -0.40913260*h1_3 + 0.10073422*h1_4 + 0.33048588*h1_5 + -0.38755932*h1_6 + -0.12777916*h1_7 + -0.06645548*h1_8 + -0.16426465*h1_9 + -0.17684512*h1_10 + -0.16443686*h1_11 + 0.03021489*h1_12 + -0.01049035*h1_13 + 0.31551793*h1_14 + -0.08290098*h1_15 + 0.02197363*h1_16 + 0.44751424*h1_17 + -0.56516892*h1_18 + 0.15192641*h1_19 + -0.21724983*h1_20 + 0.43609777*h1_21 + 0.17102817*h1_22 + -0.07886212*h1_23 + -0.66378587*h1_24 + -0.60230613*h1_25 + -0.49723390*h1_26 + 0.00487971*h1_27 + 0.36430827*h1_28 + 0.21272679*h1_29 + 0.05974614*h1_30 + 0.13392347*h1_31);
        h2_13 = tanh(0.22878975 + 0.25138974*h1_0 + -0.22058430*h1_1 + 0.21396828*h1_2 + -0.25800043*h1_3 + -0.17563635*h1_4 + -0.11897697*h1_5 + 0.11490759*h1_6 + 0.23851240*h1_7 + 0.08595438*h1_8 + -0.20052609*h1_9 + 0.49051937*h1_10 + 0.40467614*h1_11 + 0.68021089*h1_12 + 0.08341789*h1_13 + -0.02993782*h1_14 + 0.15821330*h1_15 + 0.27754429*h1_16 + -0.47442517*h1_17 + 0.34765890*h1_18 + -0.09763800*h1_19 + 0.71491534*h1_20 + 0.14660214*h1_21 + 0.05939869*h1_22 + 0.07335567*h1_23 + 0.25191787*h1_24 + -0.33062908*h1_25 + -0.68866748*h1_26 + 0.15687542*h1_27 + -0.29250130*h1_28 + 0.02930148*h1_29 + -0.04028887*h1_30 + -0.23525070*h1_31);
        h2_14 = tanh(0.20379664 + 0.08576962*h1_0 + -0.47009745*h1_1 + 0.10410891*h1_2 + 0.17586845*h1_3 + -0.09123954*h1_4 + -0.18705204*h1_5 + 0.54229015*h1_6 + 0.51840866*h1_7 + 0.36830389*h1_8 + 0.52093017*h1_9 + 0.12342366*h1_10 + 0.09350631*h1_11 + 0.22762665*h1_12 + 0.50443065*h1_13 + -0.10944039*h1_14 + 0.01917652*h1_15 + -0.15871462*h1_16 + -0.48245302*h1_17 + 0.43953556*h1_18 + 0.03473892*h1_19 + 0.05861162*h1_20 + -0.64525425*h1_21 + -0.35751778*h1_22 + 0.15687765*h1_23 + 0.94658095*h1_24 + 0.75210959*h1_25 + 0.58993930*h1_26 + -0.33334607*h1_27 + -0.51084340*h1_28 + -0.10267241*h1_29 + -0.37889063*h1_30 + -0.34653047*h1_31);
        h2_15 = tanh(-0.55292606 + -0.21098693*h1_0 + -0.03919999*h1_1 + 0.13289601*h1_2 + 0.24905589*h1_3 + -0.40942571*h1_4 + 0.67048472*h1_5 + -0.54784185*h1_6 + -0.71644467*h1_7 + -0.74087095*h1_8 + 0.21252294*h1_9 + -0.50669146*h1_10 + -0.03436772*h1_11 + -0.37492138*h1_12 + -0.61513484*h1_13 + -0.16217811*h1_14 + -0.21782155*h1_15 + -0.22434509*h1_16 + 0.18003713*h1_17 + -0.80256069*h1_18 + -0.26769626*h1_19 + 0.19918786*h1_20 + -0.00640313*h1_21 + 0.07352714*h1_22 + -0.11278890*h1_23 + 0.25702417*h1_24 + -0.04275727*h1_25 + 0.36035553*h1_26 + 0.33228856*h1_27 + 0.74220026*h1_28 + -0.18970938*h1_29 + -0.02700140*h1_30 + 0.62863016*h1_31);
        h2_16 = tanh(-0.80763799 + -0.82016581*h1_0 + 0.16580361*h1_1 + -0.13653629*h1_2 + 0.19828182*h1_3 + -0.29449242*h1_4 + 0.90568119*h1_5 + -0.70005476*h1_6 + -0.93170094*h1_7 + -0.96436614*h1_8 + 0.05297519*h1_9 + -0.71729910*h1_10 + -0.32116798*h1_11 + -0.49325702*h1_12 + -0.69347399*h1_13 + -0.43086198*h1_14 + -0.67412657*h1_15 + 0.01234195*h1_16 + 0.71112978*h1_17 + -0.92295879*h1_18 + -0.46145660*h1_19 + 0.25967821*h1_20 + 0.20692638*h1_21 + 0.17100421*h1_22 + 0.15542902*h1_23 + -0.13035884*h1_24 + 0.02407679*h1_25 + -0.57299960*h1_26 + 0.81345499*h1_27 + 1.01363087*h1_28 + -0.34077981*h1_29 + -0.06570138*h1_30 + 0.62752742*h1_31);
        h2_17 = tanh(0.81929368 + 1.34818280*h1_0 + -0.19755079*h1_1 + 0.09555262*h1_2 + -0.14721058*h1_3 + 0.29808879*h1_4 + -0.93537891*h1_5 + 0.91702741*h1_6 + 0.81236118*h1_7 + 1.00367725*h1_8 + 0.16775963*h1_9 + 1.08959436*h1_10 + 0.53755510*h1_11 + 1.16817844*h1_12 + 1.20638406*h1_13 + 0.47717413*h1_14 + 0.73054272*h1_15 + 0.00921897*h1_16 + -1.27686119*h1_17 + 0.88608199*h1_18 + 0.12743329*h1_19 + -0.25879192*h1_20 + -0.12070868*h1_21 + -0.31620011*h1_22 + -0.19109370*h1_23 + -0.02667619*h1_24 + 0.36146319*h1_25 + 0.30760017*h1_26 + -0.54285663*h1_27 + -0.94897127*h1_28 + 0.39935103*h1_29 + 0.21651252*h1_30 + -0.72988838*h1_31);
        h2_18 = tanh(-0.41870296 + -1.19999158*h1_0 + -0.05679937*h1_1 + -0.59345257*h1_2 + 0.09990778*h1_3 + 1.19528377*h1_4 + 0.42870039*h1_5 + -0.41469115*h1_6 + -0.34321713*h1_7 + -0.51615679*h1_8 + 0.26802289*h1_9 + -1.07435441*h1_10 + -0.92341506*h1_11 + -2.32954764*h1_12 + -0.63039052*h1_13 + -0.15411617*h1_14 + -0.13360265*h1_15 + 1.07248962*h1_16 + 2.13472652*h1_17 + -0.36657196*h1_18 + -0.27405411*h1_19 + 1.11732340*h1_20 + -0.32922718*h1_21 + 0.70224571*h1_22 + 0.40834022*h1_23 + -0.94675034*h1_24 + 0.04563693*h1_25 + 0.11227808*h1_26 + 0.13019356*h1_27 + 0.37227875*h1_28 + 0.89707321*h1_29 + -0.03152605*h1_30 + 0.42853257*h1_31);
        h2_19 = tanh(-0.35159686 + -0.47462109*h1_0 + -0.04869954*h1_1 + -0.04160003*h1_2 + 0.53237933*h1_3 + -0.14926685*h1_4 + 0.37360606*h1_5 + -0.30106941*h1_6 + -0.25183415*h1_7 + -0.19709703*h1_8 + -0.15844148*h1_9 + -0.39462653*h1_10 + -0.09469408*h1_11 + -0.14486568*h1_12 + -0.51533288*h1_13 + -0.11422702*h1_14 + 0.08201715*h1_15 + -0.27696517*h1_16 + 0.32741508*h1_17 + -0.24762017*h1_18 + 0.13657919*h1_19 + -0.22551152*h1_20 + 0.10647637*h1_21 + 0.02751813*h1_22 + 0.08680781*h1_23 + 0.37241110*h1_24 + 0.15673317*h1_25 + 0.24418962*h1_26 + 0.40706030*h1_27 + 0.25398919*h1_28 + -0.24127664*h1_29 + -0.02843531*h1_30 + 0.20001782*h1_31);
        h2_20 = tanh(-0.43495461 + -1.50569737*h1_0 + 0.01897236*h1_1 + -0.86967224*h1_2 + -0.27715623*h1_3 + 0.07007480*h1_4 + 0.67929637*h1_5 + -0.16575427*h1_6 + -0.30781409*h1_7 + -0.36530170*h1_8 + -0.20151822*h1_9 + -1.24386930*h1_10 + -2.03582001*h1_11 + -2.56822133*h1_12 + -0.63464332*h1_13 + 0.19768989*h1_14 + -0.36961249*h1_15 + 0.43568003*h1_16 + 3.80542660*h1_17 + -0.23286630*h1_18 + -0.18490262*h1_19 + -0.47787282*h1_20 + 0.08240632*h1_21 + 1.45974565*h1_22 + -0.30714488*h1_23 + -1.45534050*h1_24 + 0.32856771*h1_25 + 1.41213739*h1_26 + 0.26463687*h1_27 + 0.35917854*h1_28 + 0.13415043*h1_29 + 0.38861424*h1_30 + 0.59080422*h1_31);
        h2_21 = tanh(-0.67051131 + -0.57264090*h1_0 + -0.17704245*h1_1 + 0.08346827*h1_2 + 0.36507761*h1_3 + -0.30635700*h1_4 + 0.58658731*h1_5 + -0.44828287*h1_6 + -0.60748529*h1_7 + -0.80046105*h1_8 + -0.21549514*h1_9 + -0.63329053*h1_10 + -0.14354566*h1_11 + -0.20224892*h1_12 + -0.71082091*h1_13 + -0.16649042*h1_14 + -0.36829489*h1_15 + -0.21518707*h1_16 + 0.37040353*h1_17 + -0.76075703*h1_18 + -0.12122915*h1_19 + -0.09188762*h1_20 + -0.01930779*h1_21 + 0.02627523*h1_22 + 0.04025618*h1_23 + 0.11511315*h1_24 + 0.17081951*h1_25 + -0.29113653*h1_26 + 0.38263610*h1_27 + 0.56637144*h1_28 + -0.28612849*h1_29 + -0.35972595*h1_30 + 0.77549404*h1_31);
        h2_22 = tanh(-0.78441447 + -1.93828142*h1_0 + -0.05570632*h1_1 + 0.06689145*h1_2 + 0.25161010*h1_3 + -0.46225581*h1_4 + 1.27921844*h1_5 + -0.80501145*h1_6 + -0.99183941*h1_7 + -0.85182333*h1_8 + -0.32856488*h1_9 + -1.31013036*h1_10 + -0.36969474*h1_11 + -1.10773194*h1_12 + -1.01843596*h1_13 + -0.14684328*h1_14 + -0.80671281*h1_15 + -0.06405266*h1_16 + 1.19469655*h1_17 + -0.96314299*h1_18 + -0.29179257*h1_19 + 0.16431430*h1_20 + 0.26614264*h1_21 + 0.49326122*h1_22 + 0.01241185*h1_23 + -0.19618306*h1_24 + -0.46176070*h1_25 + -0.14110826*h1_26 + 0.71541244*h1_27 + 0.87005252*h1_28 + -0.36392781*h1_29 + -0.09145300*h1_30 + 1.05798686*h1_31);
        h2_23 = tanh(0.64233160 + 1.86173522*h1_0 + -0.21956819*h1_1 + 0.28846389*h1_2 + -0.00647661*h1_3 + -1.01163471*h1_4 + -1.02153623*h1_5 + 0.50739604*h1_6 + 1.16301608*h1_7 + 0.78746629*h1_8 + 0.08079474*h1_9 + 1.32349622*h1_10 + 0.61039895*h1_11 + 2.27009869*h1_12 + 1.09218705*h1_13 + -0.10256855*h1_14 + 0.81726712*h1_15 + -0.48422375*h1_16 + -1.74520338*h1_17 + 0.59461373*h1_18 + 0.02314012*h1_19 + -0.68132263*h1_20 + -0.36131069*h1_21 + -0.89233470*h1_22 + -0.06560807*h1_23 + 0.52392411*h1_24 + 0.31054002*h1_25 + 0.25305566*h1_26 + -0.18610430*h1_27 + -0.65179396*h1_28 + -0.44228992*h1_29 + -0.03961664*h1_30 + -0.99274188*h1_31);
        h2_24 = tanh(0.66627592 + 0.66917324*h1_0 + -0.02260436*h1_1 + -0.10981970*h1_2 + -0.30068725*h1_3 + 0.51206297*h1_4 + -0.75369573*h1_5 + 0.38195506*h1_6 + 0.90247583*h1_7 + 0.60102093*h1_8 + 0.07804786*h1_9 + 0.50323784*h1_10 + 0.16390331*h1_11 + 0.49787194*h1_12 + 0.54628992*h1_13 + 0.13871954*h1_14 + 0.53219992*h1_15 + 0.13768001*h1_16 + -0.35815212*h1_17 + 0.47551814*h1_18 + 0.41028160*h1_19 + -0.05016819*h1_20 + -0.07970830*h1_21 + -0.09127381*h1_22 + -0.11241857*h1_23 + -0.03399214*h1_24 + -0.04783118*h1_25 + 0.63277060*h1_26 + -0.53901869*h1_27 + -0.75849152*h1_28 + 0.44176385*h1_29 + 0.15313734*h1_30 + -0.62881237*h1_31);
        h2_25 = tanh(0.02547316 + -0.00763975*h1_0 + -1.97880578*h1_1 + -0.24190393*h1_2 + 1.46302938*h1_3 + -0.40120962*h1_4 + 0.06531154*h1_5 + 0.30522999*h1_6 + 0.26249292*h1_7 + -0.04627115*h1_8 + 1.48068380*h1_9 + 0.22147961*h1_10 + -0.03678275*h1_11 + -0.07221010*h1_12 + 0.20482898*h1_13 + -1.14849186*h1_14 + -0.22573717*h1_15 + 1.65695024*h1_16 + 0.06328179*h1_17 + 0.49469978*h1_18 + -1.12085795*h1_19 + 1.44141769*h1_20 + -1.65920115*h1_21 + -0.48170632*h1_22 + 1.55960894*h1_23 + -0.11950827*h1_24 + 1.27377856*h1_25 + -0.19340579*h1_26 + 0.20366868*h1_27 + -0.36686558*h1_28 + -0.60383153*h1_29 + -1.52452064*h1_30 + 0.26352242*h1_31);
        h2_26 = tanh(0.65560228 + 2.94688535*h1_0 + -0.13603716*h1_1 + -0.41694424*h1_2 + 0.08056088*h1_3 + 0.25774458*h1_4 + -1.23781776*h1_5 + 0.38667452*h1_6 + 1.04769611*h1_7 + 0.64334744*h1_8 + 0.43256444*h1_9 + 1.73887563*h1_10 + 0.60359448*h1_11 + 1.72578692*h1_12 + 1.21095765*h1_13 + 0.06628782*h1_14 + 0.69855797*h1_15 + 0.05388624*h1_16 + -1.48474550*h1_17 + 0.79012245*h1_18 + 0.27561155*h1_19 + -0.16538008*h1_20 + -0.49916467*h1_21 + -0.48461521*h1_22 + 0.36686453*h1_23 + 0.07823683*h1_24 + 0.54108214*h1_25 + -0.17065959*h1_26 + -0.70933193*h1_27 + -0.86223406*h1_28 + 0.35283968*h1_29 + 0.01347416*h1_30 + -0.93036240*h1_31);
        h2_27 = tanh(-0.56500500 + -2.47425818*h1_0 + 0.14366631*h1_1 + 0.17588504*h1_2 + -0.06146031*h1_3 + -0.02471155*h1_4 + 1.05581737*h1_5 + -0.69597286*h1_6 + -1.06591988*h1_7 + -0.64438850*h1_8 + -0.40754169*h1_9 + -1.53196406*h1_10 + -0.70771921*h1_11 + -2.11206770*h1_12 + -1.38432145*h1_13 + -0.09867208*h1_14 + -0.79391766*h1_15 + 0.03510085*h1_16 + 1.79067695*h1_17 + -0.83919412*h1_18 + 0.05859824*h1_19 + 0.44955745*h1_20 + 0.38943720*h1_21 + 0.91706413*h1_22 + -0.08173243*h1_23 + -0.11389083*h1_24 + -0.64926326*h1_25 + -0.08795641*h1_26 + 0.33164203*h1_27 + 0.74871927*h1_28 + 0.01963642*h1_29 + 0.14849497*h1_30 + 1.09201300*h1_31);
        h2_28 = tanh(-0.28328979 + -0.28897610*h1_0 + -0.56894976*h1_1 + -0.34718537*h1_2 + 0.33638948*h1_3 + -0.38290647*h1_4 + 0.09481009*h1_5 + -0.06962661*h1_6 + -0.38548234*h1_7 + -0.54880708*h1_8 + 0.32600445*h1_9 + -0.11038722*h1_10 + -0.05808989*h1_11 + -0.03467036*h1_12 + -0.26921907*h1_13 + -0.63565892*h1_14 + -0.44488722*h1_15 + 0.79462284*h1_16 + -0.18470688*h1_17 + 0.22576281*h1_18 + -0.24877460*h1_19 + 1.01119781*h1_20 + -0.46061182*h1_21 + -0.59435731*h1_22 + 0.42571080*h1_23 + 0.89070410*h1_24 + 0.44941634*h1_25 + 0.52837163*h1_26 + 0.55673468*h1_27 + 0.37318355*h1_28 + -0.55545807*h1_29 + -1.18429995*h1_30 + 0.32553810*h1_31);
        h2_29 = tanh(-0.62888598 + -1.51739085*h1_0 + 0.08368573*h1_1 + -0.43856397*h1_2 + 0.27558047*h1_3 + 0.41954535*h1_4 + 0.71864629*h1_5 + -0.63184071*h1_6 + -0.85474777*h1_7 + -0.69758624*h1_8 + -0.32484120*h1_9 + -1.42818391*h1_10 + -0.64713401*h1_11 + -2.08248806*h1_12 + -0.91203505*h1_13 + 0.04698062*h1_14 + -0.62302780*h1_15 + 0.51239550*h1_16 + 1.59509408*h1_17 + -0.85472488*h1_18 + -0.16914307*h1_19 + 0.72053599*h1_20 + 0.31840247*h1_21 + 0.74661601*h1_22 + 0.18039019*h1_23 + -0.39573655*h1_24 + -0.15330277*h1_25 + -0.31639618*h1_26 + 0.51804775*h1_27 + 0.90805954*h1_28 + 0.39957988*h1_29 + 0.16523305*h1_30 + 0.90336531*h1_31);
        h2_30 = tanh(-0.54784995 + -2.77999449*h1_0 + 0.47089535*h1_1 + -0.03881448*h1_2 + -0.37990066*h1_3 + -0.32932827*h1_4 + 1.21931851*h1_5 + -0.63753343*h1_6 + -1.21798515*h1_7 + -0.79973990*h1_8 + -0.64006174*h1_9 + -1.65609574*h1_10 + -0.50623786*h1_11 + -1.87844908*h1_12 + -1.19793177*h1_13 + -0.08710283*h1_14 + -0.86473870*h1_15 + 0.06546333*h1_16 + 2.01945662*h1_17 + -0.65197825*h1_18 + -0.11886750*h1_19 + 0.11430630*h1_20 + 0.47677723*h1_21 + 0.74535626*h1_22 + -0.18149032*h1_23 + -0.27528542*h1_24 + -0.82731235*h1_25 + -0.37381563*h1_26 + 0.41071421*h1_27 + 0.62939173*h1_28 + -0.23428394*h1_29 + -0.18888555*h1_30 + 1.05217171*h1_31);
        h2_31 = tanh(-0.33196592 + -2.27096128*h1_0 + -0.02815354*h1_1 + -1.50584817*h1_2 + -0.62091213*h1_3 + 0.27572101*h1_4 + 0.70521688*h1_5 + -0.29489762*h1_6 + -0.26972678*h1_7 + -0.24497986*h1_8 + -0.38124377*h1_9 + -1.65571833*h1_10 + -2.60653186*h1_11 + -3.12620974*h1_12 + -0.63953477*h1_13 + -0.20016855*h1_14 + -0.30119035*h1_15 + 0.39735955*h1_16 + 5.49845600*h1_17 + -0.22976339*h1_18 + -0.02538438*h1_19 + -0.81557506*h1_20 + 0.25332960*h1_21 + 1.66962397*h1_22 + -0.06593115*h1_23 + -3.60133672*h1_24 + -0.26830491*h1_25 + -0.26788151*h1_26 + -0.01229741*h1_27 + 0.32281238*h1_28 + 0.21286882*h1_29 + 0.25189948*h1_30 + 0.63658029*h1_31);

        // Output Layer (linear)

        log10_Id = -0.32638726 + -0.95529127*h2_0 + 0.82367527*h2_1 + 0.54892546*h2_2 + 1.04795837*h2_3 + 0.54572868*h2_4 + -0.65823883*h2_5 + -0.61760694*h2_6 + 0.92893022*h2_7 + 0.60544711*h2_8 + 0.53035814*h2_9 + -0.79809791*h2_10 + -0.93398929*h2_11 + -0.86445928*h2_12 + -0.66805512*h2_13 + 0.87109649*h2_14 + 0.61018682*h2_15 + 0.73113191*h2_16 + -0.58032024*h2_17 + 0.53806096*h2_18 + 0.68012357*h2_19 + 0.74473637*h2_20 + 0.57090724*h2_21 + 0.59266776*h2_22 + -0.55280435*h2_23 + -0.75633550*h2_24 + 0.58654171*h2_25 + -0.56241071*h2_26 + 0.76511765*h2_27 + 0.64925969*h2_28 + 0.56716245*h2_29 + 0.76525313*h2_30 + -1.88717771*h2_31;

        // Smooth output clamping to [-12, -3]
        log10_Id = -7.5 + 4.5 * tanh((log10_Id + 7.5) / 4.5);

        Ids = pow(10, log10_Id) * (W / 10e-6);

        // Smooth VDS->0 transition
        if (VDS >= 0) vds_smooth = VDS; else vds_smooth = 0;
        Ids = Ids * vds_smooth / (vds_smooth + 1e-4);

        I(d, s) <+ Ids;
        I(g, s) <+ 1e-14 * V(g, s);
        I(b, s) <+ 1e-14 * V(b, s);
    end

endmodule
