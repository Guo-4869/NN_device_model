// ============================================================
// BSIM_NN v7 - Neural Network Compact MOSFET Model
// Based on: Tung & Hu, IEEE TED 2023/2024
// Architecture: 3 inputs -> 32 ISRU -> 32 ISRU -> 32 ISRU -> 1
// ============================================================
// SPICE Convergence Features:
//   - ISRU activation: no exp(), smooth C^inf nonlinearity
//   - Smooth tanh-based input range clamping
//   - Minimum std = 0.05 to prevent division by zero
//   - Weight-regularized: |W| < 5.0 to avoid activation saturation
//   - Smooth VDS->0 transition via rational function
// ============================================================

`include "disciplines.vams"
`include "constants.vams"

module bsim_nn_v7(d, g, s, b);
    inout d, g, s, b;
    electrical d, g, s, b;

    parameter real L = 1e-6 from (0:inf);
    parameter real W  = 10e-6 from (0:inf);

    real VGS, VDS, VBS, VGS_n, VDS_n, VBS_n;
    real h1_0, h1_1, h1_2, h1_3, h1_4, h1_5, h1_6, h1_7, h1_8, h1_9, h1_10, h1_11, h1_12, h1_13, h1_14, h1_15, h1_16, h1_17, h1_18, h1_19, h1_20, h1_21, h1_22, h1_23, h1_24, h1_25, h1_26, h1_27, h1_28, h1_29, h1_30, h1_31;
    real h2_0, h2_1, h2_2, h2_3, h2_4, h2_5, h2_6, h2_7, h2_8, h2_9, h2_10, h2_11, h2_12, h2_13, h2_14, h2_15, h2_16, h2_17, h2_18, h2_19, h2_20, h2_21, h2_22, h2_23, h2_24, h2_25, h2_26, h2_27, h2_28, h2_29, h2_30, h2_31;
    real h3_0, h3_1, h3_2, h3_3, h3_4, h3_5, h3_6, h3_7, h3_8, h3_9, h3_10, h3_11, h3_12, h3_13, h3_14, h3_15, h3_16, h3_17, h3_18, h3_19, h3_20, h3_21, h3_22, h3_23, h3_24, h3_25, h3_26, h3_27, h3_28, h3_29, h3_30, h3_31;
    real log10_Id, Ids, vds_ratio;

    // ISRU: f(x) = x / sqrt(1 + x^2)
    // Bounded (-1, 1), smooth, no exp(), Verilog-A friendly

    real mean_vgs = 0.4612068966;
    real std_vgs  = 0.3736814936;
    real mean_vds = 0.4036206897;
    real std_vds  = 0.3668991111;
    real mean_vbs = -0.2500000000;
    real std_vbs  = 0.1767766953;

    analog begin
        VGS = V(g, s);
        VDS = V(d, s);
        VBS = V(b, s);

        // Smooth tanh-based input clamping
        VGS = 0.5 + 0.8 * tanh((VGS - 0.5) / 0.8);
        VDS = 0.6 + 0.7 * tanh((VDS - 0.6) / 0.7);
        VBS = -0.25 + 0.3 * tanh((VBS + 0.25) / 0.3);

        VGS_n = (VGS - mean_vgs) / std_vgs;
        VDS_n = (VDS - mean_vds) / std_vds;
        VBS_n = (VBS - mean_vbs) / std_vbs;

        // Hidden Layer 1: 3 -> 32 ISRU

        h1_0 = (-0.7151181102 + 0.0379425846*VGS_n + -0.6919497848*VDS_n + -0.0030990245*VBS_n) / sqrt(1 + pow(-0.7151181102 + 0.0379425846*VGS_n + -0.6919497848*VDS_n + -0.0030990245*VBS_n, 2));
        h1_1 = (0.0175793283 + -0.5941464305*VGS_n + -0.0847255141*VDS_n + -0.0353618190*VBS_n) / sqrt(1 + pow(0.0175793283 + -0.5941464305*VGS_n + -0.0847255141*VDS_n + -0.0353618190*VBS_n, 2));
        h1_2 = (0.0769711211 + -0.4548766315*VGS_n + -0.1398880631*VDS_n + -0.0298671741*VBS_n) / sqrt(1 + pow(0.0769711211 + -0.4548766315*VGS_n + -0.1398880631*VDS_n + -0.0298671741*VBS_n, 2));
        h1_3 = (0.0101124719 + -0.6344576478*VGS_n + 0.0309316497*VDS_n + -0.0550001487*VBS_n) / sqrt(1 + pow(0.0101124719 + -0.6344576478*VGS_n + 0.0309316497*VDS_n + -0.0550001487*VBS_n, 2));
        h1_4 = (-0.0191175602 + -0.6569867730*VGS_n + 0.2076922655*VDS_n + -0.0435115844*VBS_n) / sqrt(1 + pow(-0.0191175602 + -0.6569867730*VGS_n + 0.2076922655*VDS_n + -0.0435115844*VBS_n, 2));
        h1_5 = (0.6112781167 + 0.0353080370*VGS_n + 0.5309495926*VDS_n + -5.6660734117e-05*VBS_n) / sqrt(1 + pow(0.6112781167 + 0.0353080370*VGS_n + 0.5309495926*VDS_n + -5.6660734117e-05*VBS_n, 2));
        h1_6 = (-0.5793870091 + -0.0302186999*VGS_n + -1.1430873871*VDS_n + -0.0088303760*VBS_n) / sqrt(1 + pow(-0.5793870091 + -0.0302186999*VGS_n + -1.1430873871*VDS_n + -0.0088303760*VBS_n, 2));
        h1_7 = (-0.3331785798 + -0.0265787188*VGS_n + -0.1155414209*VDS_n + 0.0050735641*VBS_n) / sqrt(1 + pow(-0.3331785798 + -0.0265787188*VGS_n + -0.1155414209*VDS_n + 0.0050735641*VBS_n, 2));
        h1_8 = (0.0771622136 + -0.2291213721*VGS_n + -0.0381519645*VDS_n + -0.1040363833*VBS_n) / sqrt(1 + pow(0.0771622136 + -0.2291213721*VGS_n + -0.0381519645*VDS_n + -0.1040363833*VBS_n, 2));
        h1_9 = (0.1725972593 + -0.0139167896*VGS_n + -0.0009451922*VDS_n + -0.0383831710*VBS_n) / sqrt(1 + pow(0.1725972593 + -0.0139167896*VGS_n + -0.0009451922*VDS_n + -0.0383831710*VBS_n, 2));
        h1_10 = (-0.4046212733 + 0.0282616690*VGS_n + -0.3739931583*VDS_n + 0.0003772806*VBS_n) / sqrt(1 + pow(-0.4046212733 + 0.0282616690*VGS_n + -0.3739931583*VDS_n + 0.0003772806*VBS_n, 2));
        h1_11 = (0.1665048152 + -0.3667104840*VGS_n + -0.2021843493*VDS_n + -0.0808083713*VBS_n) / sqrt(1 + pow(0.1665048152 + -0.3667104840*VGS_n + -0.2021843493*VDS_n + -0.0808083713*VBS_n, 2));
        h1_12 = (0.5801590085 + 0.0686051324*VGS_n + 0.4488415420*VDS_n + 0.0116122942*VBS_n) / sqrt(1 + pow(0.5801590085 + 0.0686051324*VGS_n + 0.4488415420*VDS_n + 0.0116122942*VBS_n, 2));
        h1_13 = (-0.3370967507 + -0.0244673453*VGS_n + -0.1207456887*VDS_n + -0.0148101132*VBS_n) / sqrt(1 + pow(-0.3370967507 + -0.0244673453*VGS_n + -0.1207456887*VDS_n + -0.0148101132*VBS_n, 2));
        h1_14 = (-0.0566714332 + -0.8016045690*VGS_n + -0.3824392259*VDS_n + -0.0803729892*VBS_n) / sqrt(1 + pow(-0.0566714332 + -0.8016045690*VGS_n + -0.3824392259*VDS_n + -0.0803729892*VBS_n, 2));
        h1_15 = (-0.7018198371 + -0.0239697173*VGS_n + -0.6632022858*VDS_n + -0.0009303506*VBS_n) / sqrt(1 + pow(-0.7018198371 + -0.0239697173*VGS_n + -0.6632022858*VDS_n + -0.0009303506*VBS_n, 2));
        h1_16 = (0.1886882186 + -0.0568496175*VGS_n + 0.2524833381*VDS_n + -0.0358765572*VBS_n) / sqrt(1 + pow(0.1886882186 + -0.0568496175*VGS_n + 0.2524833381*VDS_n + -0.0358765572*VBS_n, 2));
        h1_17 = (-0.6326409578 + 0.0110722743*VGS_n + -0.5733373165*VDS_n + 0.0101721305*VBS_n) / sqrt(1 + pow(-0.6326409578 + 0.0110722743*VGS_n + -0.5733373165*VDS_n + 0.0101721305*VBS_n, 2));
        h1_18 = (-0.5087573528 + -0.0437433310*VGS_n + -0.3874987066*VDS_n + -0.0054767518*VBS_n) / sqrt(1 + pow(-0.5087573528 + -0.0437433310*VGS_n + -0.3874987066*VDS_n + -0.0054767518*VBS_n, 2));
        h1_19 = (0.3575133383 + -0.0101368614*VGS_n + 0.3279509246*VDS_n + -0.0162917413*VBS_n) / sqrt(1 + pow(0.3575133383 + -0.0101368614*VGS_n + 0.3279509246*VDS_n + -0.0162917413*VBS_n, 2));
        h1_20 = (0.4405738711 + -0.0326974727*VGS_n + 0.4058904648*VDS_n + -0.0039002243*VBS_n) / sqrt(1 + pow(0.4405738711 + -0.0326974727*VGS_n + 0.4058904648*VDS_n + -0.0039002243*VBS_n, 2));
        h1_21 = (-0.2126314491 + 0.0047465693*VGS_n + 0.0283116549*VDS_n + -0.0107454667*VBS_n) / sqrt(1 + pow(-0.2126314491 + 0.0047465693*VGS_n + 0.0283116549*VDS_n + -0.0107454667*VBS_n, 2));
        h1_22 = (-0.0850291476 + 0.7401853800*VGS_n + 0.0429931097*VDS_n + 0.0253818445*VBS_n) / sqrt(1 + pow(-0.0850291476 + 0.7401853800*VGS_n + 0.0429931097*VDS_n + 0.0253818445*VBS_n, 2));
        h1_23 = (0.2662702501 + -0.0790299550*VGS_n + 0.0963845626*VDS_n + 0.1981101185*VBS_n) / sqrt(1 + pow(0.2662702501 + -0.0790299550*VGS_n + 0.0963845626*VDS_n + 0.1981101185*VBS_n, 2));
        h1_24 = (0.2126139849 + 0.1057967320*VGS_n + 0.0527842231*VDS_n + 0.0188796371*VBS_n) / sqrt(1 + pow(0.2126139849 + 0.1057967320*VGS_n + 0.0527842231*VDS_n + 0.0188796371*VBS_n, 2));
        h1_25 = (0.4474797547 + -0.1184564009*VGS_n + 0.5160073638*VDS_n + -0.0048405319*VBS_n) / sqrt(1 + pow(0.4474797547 + -0.1184564009*VGS_n + 0.5160073638*VDS_n + -0.0048405319*VBS_n, 2));
        h1_26 = (-0.3687607348 + -0.0418975279*VGS_n + -0.2406431735*VDS_n + 0.0060931309*VBS_n) / sqrt(1 + pow(-0.3687607348 + -0.0418975279*VGS_n + -0.2406431735*VDS_n + 0.0060931309*VBS_n, 2));
        h1_27 = (-0.2520678937 + -0.1502958089*VGS_n + 0.1369732320*VDS_n + -0.0009092315*VBS_n) / sqrt(1 + pow(-0.2520678937 + -0.1502958089*VGS_n + 0.1369732320*VDS_n + -0.0009092315*VBS_n, 2));
        h1_28 = (-0.2615657449 + 0.0446782149*VGS_n + -0.2630150318*VDS_n + -0.0006106129*VBS_n) / sqrt(1 + pow(-0.2615657449 + 0.0446782149*VGS_n + -0.2630150318*VDS_n + -0.0006106129*VBS_n, 2));
        h1_29 = (-0.7567860484 + 0.0063060527*VGS_n + -0.6893059015*VDS_n + -0.0060635949*VBS_n) / sqrt(1 + pow(-0.7567860484 + 0.0063060527*VGS_n + -0.6893059015*VDS_n + -0.0060635949*VBS_n, 2));
        h1_30 = (0.2670581639 + -0.0854771882*VGS_n + 0.3510657251*VDS_n + -0.0088692345*VBS_n) / sqrt(1 + pow(0.2670581639 + -0.0854771882*VGS_n + 0.3510657251*VDS_n + -0.0088692345*VBS_n, 2));
        h1_31 = (0.7215746045 + 0.0754423663*VGS_n + 0.6355800629*VDS_n + -0.0063791140*VBS_n) / sqrt(1 + pow(0.7215746045 + 0.0754423663*VGS_n + 0.6355800629*VDS_n + -0.0063791140*VBS_n, 2));

        // Hidden Layer 2: 32 -> 32 ISRU

        h2_0 = (-0.1397791207 + 0.2144533843*h1_0 + 0.1331460923*h1_1 + -0.0696735010*h1_2 + -0.1974854171*h1_3 + -0.0448163636*h1_4 + 0.0395058990*h1_5 + -0.0896718502*h1_6 + -0.2104306668*h1_7 + -0.0219638087*h1_8 + -0.0035441725*h1_9 + -0.0317606740*h1_10 + -0.2021732479*h1_11 + 0.0078684082*h1_12 + -0.2241986096*h1_13 + -0.0903718099*h1_14 + -0.3343817890*h1_15 + 0.2476134896*h1_16 + 0.1680279523*h1_17 + -0.2657986283*h1_18 + 0.1689727157*h1_19 + -0.0751442462*h1_20 + -0.2051053792*h1_21 + 0.0064395131*h1_22 + -0.0858510956*h1_23 + -0.1338866055*h1_24 + -0.1725845337*h1_25 + -0.2040636539*h1_26 + 0.1908443719*h1_27 + 0.0184032600*h1_28 + -0.0966549739*h1_29 + -0.0224862043*h1_30 + -0.0759928897*h1_31) / sqrt(1 + pow(-0.1397791207 + 0.2144533843*h1_0 + 0.1331460923*h1_1 + -0.0696735010*h1_2 + -0.1974854171*h1_3 + -0.0448163636*h1_4 + 0.0395058990*h1_5 + -0.0896718502*h1_6 + -0.2104306668*h1_7 + -0.0219638087*h1_8 + -0.0035441725*h1_9 + -0.0317606740*h1_10 + -0.2021732479*h1_11 + 0.0078684082*h1_12 + -0.2241986096*h1_13 + -0.0903718099*h1_14 + -0.3343817890*h1_15 + 0.2476134896*h1_16 + 0.1680279523*h1_17 + -0.2657986283*h1_18 + 0.1689727157*h1_19 + -0.0751442462*h1_20 + -0.2051053792*h1_21 + 0.0064395131*h1_22 + -0.0858510956*h1_23 + -0.1338866055*h1_24 + -0.1725845337*h1_25 + -0.2040636539*h1_26 + 0.1908443719*h1_27 + 0.0184032600*h1_28 + -0.0966549739*h1_29 + -0.0224862043*h1_30 + -0.0759928897*h1_31, 2));
        h2_1 = (0.0310018826 + -2.3698227406*h1_0 + -0.1593490690*h1_1 + 0.1353837699*h1_2 + -0.0050128014*h1_3 + -0.0681685209*h1_4 + 2.1006855965*h1_5 + -0.2779416442*h1_6 + -0.4393540323*h1_7 + -0.0631646141*h1_8 + 0.1119335070*h1_9 + -1.2483559847*h1_10 + 0.1692723930*h1_11 + 0.5374109149*h1_12 + -0.4133156836*h1_13 + 0.0693356320*h1_14 + -3.1413564682*h1_15 + 0.3716174662*h1_16 + -2.3405151367*h1_17 + -0.7930346131*h1_18 + 1.3644738197*h1_19 + 1.7417826653*h1_20 + -0.1702210903*h1_21 + 0.1182748973*h1_22 + 0.2256370038*h1_23 + 0.5615230799*h1_24 + 0.6220495701*h1_25 + -0.4318203926*h1_26 + -0.1769324988*h1_27 + -0.4747165442*h1_28 + -3.1246228218*h1_29 + 0.1457927674*h1_30 + 1.1707922220*h1_31) / sqrt(1 + pow(0.0310018826 + -2.3698227406*h1_0 + -0.1593490690*h1_1 + 0.1353837699*h1_2 + -0.0050128014*h1_3 + -0.0681685209*h1_4 + 2.1006855965*h1_5 + -0.2779416442*h1_6 + -0.4393540323*h1_7 + -0.0631646141*h1_8 + 0.1119335070*h1_9 + -1.2483559847*h1_10 + 0.1692723930*h1_11 + 0.5374109149*h1_12 + -0.4133156836*h1_13 + 0.0693356320*h1_14 + -3.1413564682*h1_15 + 0.3716174662*h1_16 + -2.3405151367*h1_17 + -0.7930346131*h1_18 + 1.3644738197*h1_19 + 1.7417826653*h1_20 + -0.1702210903*h1_21 + 0.1182748973*h1_22 + 0.2256370038*h1_23 + 0.5615230799*h1_24 + 0.6220495701*h1_25 + -0.4318203926*h1_26 + -0.1769324988*h1_27 + -0.4747165442*h1_28 + -3.1246228218*h1_29 + 0.1457927674*h1_30 + 1.1707922220*h1_31, 2));
        h2_2 = (-0.1799417585 + 0.0637112558*h1_0 + 1.5484403372*h1_1 + 0.9216714501*h1_2 + 1.4657374620*h1_3 + 1.2070717812*h1_4 + 0.1573956907*h1_5 + 0.0341117866*h1_6 + 0.4845336378*h1_7 + 0.7598195672*h1_8 + 0.2280637026*h1_9 + 0.8648690581*h1_10 + 0.8112573028*h1_11 + -0.9799235463*h1_12 + 0.5312585831*h1_13 + 1.2668558359*h1_14 + -0.0543476492*h1_15 + 0.2372135520*h1_16 + -0.7241911292*h1_17 + 0.3902919292*h1_18 + 0.0106486557*h1_19 + 0.1155968532*h1_20 + 0.0204146933*h1_21 + -1.8858402967*h1_22 + 0.6512169838*h1_23 + -0.7241448164*h1_24 + 0.4882915914*h1_25 + 0.0262515638*h1_26 + 1.0166819096*h1_27 + -0.3398166597*h1_28 + -0.3335947692*h1_29 + 0.2422267199*h1_30 + 0.2927337885*h1_31) / sqrt(1 + pow(-0.1799417585 + 0.0637112558*h1_0 + 1.5484403372*h1_1 + 0.9216714501*h1_2 + 1.4657374620*h1_3 + 1.2070717812*h1_4 + 0.1573956907*h1_5 + 0.0341117866*h1_6 + 0.4845336378*h1_7 + 0.7598195672*h1_8 + 0.2280637026*h1_9 + 0.8648690581*h1_10 + 0.8112573028*h1_11 + -0.9799235463*h1_12 + 0.5312585831*h1_13 + 1.2668558359*h1_14 + -0.0543476492*h1_15 + 0.2372135520*h1_16 + -0.7241911292*h1_17 + 0.3902919292*h1_18 + 0.0106486557*h1_19 + 0.1155968532*h1_20 + 0.0204146933*h1_21 + -1.8858402967*h1_22 + 0.6512169838*h1_23 + -0.7241448164*h1_24 + 0.4882915914*h1_25 + 0.0262515638*h1_26 + 1.0166819096*h1_27 + -0.3398166597*h1_28 + -0.3335947692*h1_29 + 0.2422267199*h1_30 + 0.2927337885*h1_31, 2));
        h2_3 = (-0.1731123477 + -0.2048804611*h1_0 + 0.2852146029*h1_1 + -0.0542238802*h1_2 + 0.2498581260*h1_3 + -0.0623769350*h1_4 + 0.0895760283*h1_5 + -0.5670829415*h1_6 + -0.0982894525*h1_7 + 0.1664012969*h1_8 + -0.0840398446*h1_9 + -0.2558017075*h1_10 + 0.1359169185*h1_11 + 0.1668588370*h1_12 + 0.0060149357*h1_13 + 0.0005035551*h1_14 + -0.4161165655*h1_15 + 0.1183942109*h1_16 + 0.0441999733*h1_17 + -0.1773698032*h1_18 + 0.1133069694*h1_19 + -0.0025071355*h1_20 + -0.0920505002*h1_21 + -0.0860049427*h1_22 + 0.1572015584*h1_23 + 0.0301476307*h1_24 + 0.2016506344*h1_25 + 0.1110197306*h1_26 + 0.1132263392*h1_27 + -0.3003197312*h1_28 + -0.1647231281*h1_29 + 0.2561962605*h1_30 + 0.2645340860*h1_31) / sqrt(1 + pow(-0.1731123477 + -0.2048804611*h1_0 + 0.2852146029*h1_1 + -0.0542238802*h1_2 + 0.2498581260*h1_3 + -0.0623769350*h1_4 + 0.0895760283*h1_5 + -0.5670829415*h1_6 + -0.0982894525*h1_7 + 0.1664012969*h1_8 + -0.0840398446*h1_9 + -0.2558017075*h1_10 + 0.1359169185*h1_11 + 0.1668588370*h1_12 + 0.0060149357*h1_13 + 0.0005035551*h1_14 + -0.4161165655*h1_15 + 0.1183942109*h1_16 + 0.0441999733*h1_17 + -0.1773698032*h1_18 + 0.1133069694*h1_19 + -0.0025071355*h1_20 + -0.0920505002*h1_21 + -0.0860049427*h1_22 + 0.1572015584*h1_23 + 0.0301476307*h1_24 + 0.2016506344*h1_25 + 0.1110197306*h1_26 + 0.1132263392*h1_27 + -0.3003197312*h1_28 + -0.1647231281*h1_29 + 0.2561962605*h1_30 + 0.2645340860*h1_31, 2));
        h2_4 = (-0.2566776574 + 0.1665769964*h1_0 + 0.0984108523*h1_1 + -0.0523161478*h1_2 + 0.1121577770*h1_3 + -0.1441437006*h1_4 + -0.1220981702*h1_5 + 0.0836765170*h1_6 + -0.1320173144*h1_7 + -0.1744465828*h1_8 + -0.2616641819*h1_9 + 0.0364169516*h1_10 + -0.0557208918*h1_11 + -0.0474608727*h1_12 + -0.0666717961*h1_13 + 0.1911770254*h1_14 + -0.3919977844*h1_15 + 0.1095962375*h1_16 + 0.2782898545*h1_17 + -0.1066808105*h1_18 + -0.1014829427*h1_19 + 0.0071495157*h1_20 + 0.3175248504*h1_21 + -0.0132806199*h1_22 + 0.1229667366*h1_23 + -0.2015134841*h1_24 + -0.2451193482*h1_25 + 0.2455801666*h1_26 + 0.0698031709*h1_27 + 0.2954421639*h1_28 + 0.1402576268*h1_29 + -0.0767166391*h1_30 + 0.2161602378*h1_31) / sqrt(1 + pow(-0.2566776574 + 0.1665769964*h1_0 + 0.0984108523*h1_1 + -0.0523161478*h1_2 + 0.1121577770*h1_3 + -0.1441437006*h1_4 + -0.1220981702*h1_5 + 0.0836765170*h1_6 + -0.1320173144*h1_7 + -0.1744465828*h1_8 + -0.2616641819*h1_9 + 0.0364169516*h1_10 + -0.0557208918*h1_11 + -0.0474608727*h1_12 + -0.0666717961*h1_13 + 0.1911770254*h1_14 + -0.3919977844*h1_15 + 0.1095962375*h1_16 + 0.2782898545*h1_17 + -0.1066808105*h1_18 + -0.1014829427*h1_19 + 0.0071495157*h1_20 + 0.3175248504*h1_21 + -0.0132806199*h1_22 + 0.1229667366*h1_23 + -0.2015134841*h1_24 + -0.2451193482*h1_25 + 0.2455801666*h1_26 + 0.0698031709*h1_27 + 0.2954421639*h1_28 + 0.1402576268*h1_29 + -0.0767166391*h1_30 + 0.2161602378*h1_31, 2));
        h2_5 = (0.2545540631 + 0.1124945879*h1_0 + 0.0393842570*h1_1 + -0.1059168801*h1_2 + 0.0081193130*h1_3 + -0.0915324911*h1_4 + 0.2152897418*h1_5 + -0.1275411099*h1_6 + -0.0356150195*h1_7 + 0.1422637552*h1_8 + 0.1297640353*h1_9 + -0.2588257492*h1_10 + 0.2068090737*h1_11 + 0.1802721322*h1_12 + -0.2278176546*h1_13 + 0.1651246101*h1_14 + 0.3172339797*h1_15 + -0.0412206165*h1_16 + -0.2677801549*h1_17 + -0.1200805530*h1_18 + -0.1111616716*h1_19 + 0.3091111183*h1_20 + 0.0413329080*h1_21 + -0.0442792475*h1_22 + 0.1784879714*h1_23 + 0.0074081640*h1_24 + 0.0958400592*h1_25 + -0.2358440906*h1_26 + -0.1278912425*h1_27 + 0.0146736139*h1_28 + -0.0707818568*h1_29 + 0.0023640958*h1_30 + -0.0600100830*h1_31) / sqrt(1 + pow(0.2545540631 + 0.1124945879*h1_0 + 0.0393842570*h1_1 + -0.1059168801*h1_2 + 0.0081193130*h1_3 + -0.0915324911*h1_4 + 0.2152897418*h1_5 + -0.1275411099*h1_6 + -0.0356150195*h1_7 + 0.1422637552*h1_8 + 0.1297640353*h1_9 + -0.2588257492*h1_10 + 0.2068090737*h1_11 + 0.1802721322*h1_12 + -0.2278176546*h1_13 + 0.1651246101*h1_14 + 0.3172339797*h1_15 + -0.0412206165*h1_16 + -0.2677801549*h1_17 + -0.1200805530*h1_18 + -0.1111616716*h1_19 + 0.3091111183*h1_20 + 0.0413329080*h1_21 + -0.0442792475*h1_22 + 0.1784879714*h1_23 + 0.0074081640*h1_24 + 0.0958400592*h1_25 + -0.2358440906*h1_26 + -0.1278912425*h1_27 + 0.0146736139*h1_28 + -0.0707818568*h1_29 + 0.0023640958*h1_30 + -0.0600100830*h1_31, 2));
        h2_6 = (-0.3050627112 + 0.2221056223*h1_0 + 0.1019823849*h1_1 + -0.0205033477*h1_2 + -0.1133608148*h1_3 + 0.0292718485*h1_4 + -0.0366094112*h1_5 + 0.3515336812*h1_6 + 0.1728156507*h1_7 + -0.0395784564*h1_8 + -0.0870354846*h1_9 + 0.2389390618*h1_10 + -0.0575470664*h1_11 + 0.1488368809*h1_12 + 0.2415823042*h1_13 + -0.2208061963*h1_14 + -0.2613316476*h1_15 + -0.0751271099*h1_16 + -0.0288188457*h1_17 + 0.1041197255*h1_18 + -0.1493250132*h1_19 + -0.2124430239*h1_20 + 0.3453625143*h1_21 + -0.0740306303*h1_22 + -0.0901468471*h1_23 + -0.1384726912*h1_24 + -0.0877421275*h1_25 + 0.1325960904*h1_26 + 0.3447684646*h1_27 + 0.0048426609*h1_28 + 0.0283025056*h1_29 + 0.1139828712*h1_30 + 0.1395062953*h1_31) / sqrt(1 + pow(-0.3050627112 + 0.2221056223*h1_0 + 0.1019823849*h1_1 + -0.0205033477*h1_2 + -0.1133608148*h1_3 + 0.0292718485*h1_4 + -0.0366094112*h1_5 + 0.3515336812*h1_6 + 0.1728156507*h1_7 + -0.0395784564*h1_8 + -0.0870354846*h1_9 + 0.2389390618*h1_10 + -0.0575470664*h1_11 + 0.1488368809*h1_12 + 0.2415823042*h1_13 + -0.2208061963*h1_14 + -0.2613316476*h1_15 + -0.0751271099*h1_16 + -0.0288188457*h1_17 + 0.1041197255*h1_18 + -0.1493250132*h1_19 + -0.2124430239*h1_20 + 0.3453625143*h1_21 + -0.0740306303*h1_22 + -0.0901468471*h1_23 + -0.1384726912*h1_24 + -0.0877421275*h1_25 + 0.1325960904*h1_26 + 0.3447684646*h1_27 + 0.0048426609*h1_28 + 0.0283025056*h1_29 + 0.1139828712*h1_30 + 0.1395062953*h1_31, 2));
        h2_7 = (0.2918367386 + -0.1293333471*h1_0 + 0.1078316495*h1_1 + 0.0276851375*h1_2 + 0.1234351695*h1_3 + 0.0706122592*h1_4 + 0.2664114833*h1_5 + -0.1246688366*h1_6 + -0.3247663081*h1_7 + -0.1174403578*h1_8 + 0.0988781527*h1_9 + -0.0829168186*h1_10 + -0.0808043927*h1_11 + 0.2821110189*h1_12 + -0.1315009147*h1_13 + 0.0048136059*h1_14 + 0.1902150512*h1_15 + -0.1064657867*h1_16 + 0.0545458756*h1_17 + -0.1044160649*h1_18 + 0.2608649433*h1_19 + -0.0083015338*h1_20 + -0.2172242552*h1_21 + 0.0003515998*h1_22 + 0.1623567939*h1_23 + 0.2306438237*h1_24 + 0.0651747733*h1_25 + -0.3277369738*h1_26 + -0.1474243999*h1_27 + -0.1637751460*h1_28 + -0.3617692292*h1_29 + -0.0163988583*h1_30 + -0.0823863223*h1_31) / sqrt(1 + pow(0.2918367386 + -0.1293333471*h1_0 + 0.1078316495*h1_1 + 0.0276851375*h1_2 + 0.1234351695*h1_3 + 0.0706122592*h1_4 + 0.2664114833*h1_5 + -0.1246688366*h1_6 + -0.3247663081*h1_7 + -0.1174403578*h1_8 + 0.0988781527*h1_9 + -0.0829168186*h1_10 + -0.0808043927*h1_11 + 0.2821110189*h1_12 + -0.1315009147*h1_13 + 0.0048136059*h1_14 + 0.1902150512*h1_15 + -0.1064657867*h1_16 + 0.0545458756*h1_17 + -0.1044160649*h1_18 + 0.2608649433*h1_19 + -0.0083015338*h1_20 + -0.2172242552*h1_21 + 0.0003515998*h1_22 + 0.1623567939*h1_23 + 0.2306438237*h1_24 + 0.0651747733*h1_25 + -0.3277369738*h1_26 + -0.1474243999*h1_27 + -0.1637751460*h1_28 + -0.3617692292*h1_29 + -0.0163988583*h1_30 + -0.0823863223*h1_31, 2));
        h2_8 = (-0.2626161575 + 0.3837252557*h1_0 + -0.1278906614*h1_1 + 0.0511306822*h1_2 + 0.1044330299*h1_3 + -0.2082909495*h1_4 + -0.0236243457*h1_5 + 0.2533704937*h1_6 + 0.2016513646*h1_7 + 0.1831648797*h1_8 + -0.1823712289*h1_9 + 0.0461275354*h1_10 + 0.1296350062*h1_11 + -0.0454300903*h1_12 + 0.0886651576*h1_13 + 0.1838221103*h1_14 + -0.4163997471*h1_15 + -0.0372036807*h1_16 + 0.3928893507*h1_17 + 0.1773828715*h1_18 + -0.3697874546*h1_19 + -0.2084116787*h1_20 + -0.0291054435*h1_21 + -0.1080849990*h1_22 + 0.0892607495*h1_23 + -0.1048450992*h1_24 + -0.3033237457*h1_25 + 0.1408449858*h1_26 + 0.1269326806*h1_27 + 0.0138190798*h1_28 + 0.0855535939*h1_29 + -0.2497832030*h1_30 + -0.0242865756*h1_31) / sqrt(1 + pow(-0.2626161575 + 0.3837252557*h1_0 + -0.1278906614*h1_1 + 0.0511306822*h1_2 + 0.1044330299*h1_3 + -0.2082909495*h1_4 + -0.0236243457*h1_5 + 0.2533704937*h1_6 + 0.2016513646*h1_7 + 0.1831648797*h1_8 + -0.1823712289*h1_9 + 0.0461275354*h1_10 + 0.1296350062*h1_11 + -0.0454300903*h1_12 + 0.0886651576*h1_13 + 0.1838221103*h1_14 + -0.4163997471*h1_15 + -0.0372036807*h1_16 + 0.3928893507*h1_17 + 0.1773828715*h1_18 + -0.3697874546*h1_19 + -0.2084116787*h1_20 + -0.0291054435*h1_21 + -0.1080849990*h1_22 + 0.0892607495*h1_23 + -0.1048450992*h1_24 + -0.3033237457*h1_25 + 0.1408449858*h1_26 + 0.1269326806*h1_27 + 0.0138190798*h1_28 + 0.0855535939*h1_29 + -0.2497832030*h1_30 + -0.0242865756*h1_31, 2));
        h2_9 = (-0.2900394499 + 0.0384881720*h1_0 + -0.0680424422*h1_1 + -0.0921905637*h1_2 + -0.2061078846*h1_3 + -0.0678915009*h1_4 + -0.2816151977*h1_5 + 0.0496018045*h1_6 + 0.0727163032*h1_7 + -0.1751410365*h1_8 + -0.2568731308*h1_9 + 0.3060662448*h1_10 + -0.0583730675*h1_11 + -0.1326407492*h1_12 + 0.1353551298*h1_13 + 0.1580904573*h1_14 + -0.4874422252*h1_15 + -0.1838724613*h1_16 + 0.0756975859*h1_17 + 0.1085295752*h1_18 + -0.0784263089*h1_19 + -0.3451595902*h1_20 + 0.2881316841*h1_21 + -0.0883269385*h1_22 + 0.1181934401*h1_23 + -0.1952535510*h1_24 + -0.1606838554*h1_25 + 0.1135689169*h1_26 + -0.0505199879*h1_27 + 0.3041543663*h1_28 + 0.0446222760*h1_29 + -0.0972501487*h1_30 + -0.1772414446*h1_31) / sqrt(1 + pow(-0.2900394499 + 0.0384881720*h1_0 + -0.0680424422*h1_1 + -0.0921905637*h1_2 + -0.2061078846*h1_3 + -0.0678915009*h1_4 + -0.2816151977*h1_5 + 0.0496018045*h1_6 + 0.0727163032*h1_7 + -0.1751410365*h1_8 + -0.2568731308*h1_9 + 0.3060662448*h1_10 + -0.0583730675*h1_11 + -0.1326407492*h1_12 + 0.1353551298*h1_13 + 0.1580904573*h1_14 + -0.4874422252*h1_15 + -0.1838724613*h1_16 + 0.0756975859*h1_17 + 0.1085295752*h1_18 + -0.0784263089*h1_19 + -0.3451595902*h1_20 + 0.2881316841*h1_21 + -0.0883269385*h1_22 + 0.1181934401*h1_23 + -0.1952535510*h1_24 + -0.1606838554*h1_25 + 0.1135689169*h1_26 + -0.0505199879*h1_27 + 0.3041543663*h1_28 + 0.0446222760*h1_29 + -0.0972501487*h1_30 + -0.1772414446*h1_31, 2));
        h2_10 = (0.1037565842 + 0.0335350819*h1_0 + 0.2484270781*h1_1 + 0.2225784063*h1_2 + 0.1286688745*h1_3 + -0.0221985355*h1_4 + 0.1375987530*h1_5 + 0.0602166764*h1_6 + 0.1837962270*h1_7 + -0.1414115876*h1_8 + -0.1800706685*h1_9 + -0.1870141178*h1_10 + 0.2817587256*h1_11 + 0.0101862215*h1_12 + -0.0870715827*h1_13 + -0.0859857947*h1_14 + 0.1610355526*h1_15 + -0.0215063356*h1_16 + 0.0864885375*h1_17 + -0.0374135710*h1_18 + -0.0010222484*h1_19 + -0.1212730706*h1_20 + 0.0770239234*h1_21 + -0.1940895617*h1_22 + 0.0537809283*h1_23 + 0.1652720124*h1_24 + 0.2182586640*h1_25 + 0.1179319844*h1_26 + 0.1522361338*h1_27 + 0.2768521309*h1_28 + 0.0217373706*h1_29 + 0.0288051665*h1_30 + 0.0425148942*h1_31) / sqrt(1 + pow(0.1037565842 + 0.0335350819*h1_0 + 0.2484270781*h1_1 + 0.2225784063*h1_2 + 0.1286688745*h1_3 + -0.0221985355*h1_4 + 0.1375987530*h1_5 + 0.0602166764*h1_6 + 0.1837962270*h1_7 + -0.1414115876*h1_8 + -0.1800706685*h1_9 + -0.1870141178*h1_10 + 0.2817587256*h1_11 + 0.0101862215*h1_12 + -0.0870715827*h1_13 + -0.0859857947*h1_14 + 0.1610355526*h1_15 + -0.0215063356*h1_16 + 0.0864885375*h1_17 + -0.0374135710*h1_18 + -0.0010222484*h1_19 + -0.1212730706*h1_20 + 0.0770239234*h1_21 + -0.1940895617*h1_22 + 0.0537809283*h1_23 + 0.1652720124*h1_24 + 0.2182586640*h1_25 + 0.1179319844*h1_26 + 0.1522361338*h1_27 + 0.2768521309*h1_28 + 0.0217373706*h1_29 + 0.0288051665*h1_30 + 0.0425148942*h1_31, 2));
        h2_11 = (0.2139146477 + 0.2152950019*h1_0 + 0.2075257003*h1_1 + -0.0395600982*h1_2 + -0.0375030451*h1_3 + -0.1642079055*h1_4 + -0.0438922159*h1_5 + -0.4061471224*h1_6 + 0.0123363025*h1_7 + 0.0081910659*h1_8 + 0.0422221757*h1_9 + 0.0522906519*h1_10 + -0.0363653600*h1_11 + 0.0659297332*h1_12 + 0.0062516881*h1_13 + -0.1613364965*h1_14 + 0.8035449982*h1_15 + 0.0804066435*h1_16 + 0.1590339690*h1_17 + 0.0730668455*h1_18 + 0.1113849953*h1_19 + -0.1311231554*h1_20 + -0.0886800438*h1_21 + 0.0714994147*h1_22 + 0.0599063337*h1_23 + 0.0862726793*h1_24 + -0.2536079586*h1_25 + 0.1624359339*h1_26 + -0.1612127125*h1_27 + 0.2206600159*h1_28 + 0.2421115190*h1_29 + -0.0597922541*h1_30 + 0.0487830266*h1_31) / sqrt(1 + pow(0.2139146477 + 0.2152950019*h1_0 + 0.2075257003*h1_1 + -0.0395600982*h1_2 + -0.0375030451*h1_3 + -0.1642079055*h1_4 + -0.0438922159*h1_5 + -0.4061471224*h1_6 + 0.0123363025*h1_7 + 0.0081910659*h1_8 + 0.0422221757*h1_9 + 0.0522906519*h1_10 + -0.0363653600*h1_11 + 0.0659297332*h1_12 + 0.0062516881*h1_13 + -0.1613364965*h1_14 + 0.8035449982*h1_15 + 0.0804066435*h1_16 + 0.1590339690*h1_17 + 0.0730668455*h1_18 + 0.1113849953*h1_19 + -0.1311231554*h1_20 + -0.0886800438*h1_21 + 0.0714994147*h1_22 + 0.0599063337*h1_23 + 0.0862726793*h1_24 + -0.2536079586*h1_25 + 0.1624359339*h1_26 + -0.1612127125*h1_27 + 0.2206600159*h1_28 + 0.2421115190*h1_29 + -0.0597922541*h1_30 + 0.0487830266*h1_31, 2));
        h2_12 = (-0.2550348341 + 0.1660471410*h1_0 + 0.0248304978*h1_1 + -0.1720557362*h1_2 + 0.0849984139*h1_3 + -0.0262973830*h1_4 + 0.0928578749*h1_5 + 0.0324774124*h1_6 + 0.1831739396*h1_7 + 0.1235058755*h1_8 + -0.2576397955*h1_9 + 0.1598973125*h1_10 + -0.2488007843*h1_11 + -0.1058131307*h1_12 + -0.1221107319*h1_13 + 0.0062853983*h1_14 + -0.5200119019*h1_15 + -0.1112704650*h1_16 + 0.0444161035*h1_17 + 0.0826508254*h1_18 + -0.2694344521*h1_19 + -0.2300606668*h1_20 + 0.1456457227*h1_21 + 0.0939000025*h1_22 + -0.1775635332*h1_23 + 0.1038800329*h1_24 + -0.2862158716*h1_25 + -0.1268335283*h1_26 + -0.0150441630*h1_27 + 0.0196202360*h1_28 + 0.2780441046*h1_29 + -0.1786803901*h1_30 + -0.0123723047*h1_31) / sqrt(1 + pow(-0.2550348341 + 0.1660471410*h1_0 + 0.0248304978*h1_1 + -0.1720557362*h1_2 + 0.0849984139*h1_3 + -0.0262973830*h1_4 + 0.0928578749*h1_5 + 0.0324774124*h1_6 + 0.1831739396*h1_7 + 0.1235058755*h1_8 + -0.2576397955*h1_9 + 0.1598973125*h1_10 + -0.2488007843*h1_11 + -0.1058131307*h1_12 + -0.1221107319*h1_13 + 0.0062853983*h1_14 + -0.5200119019*h1_15 + -0.1112704650*h1_16 + 0.0444161035*h1_17 + 0.0826508254*h1_18 + -0.2694344521*h1_19 + -0.2300606668*h1_20 + 0.1456457227*h1_21 + 0.0939000025*h1_22 + -0.1775635332*h1_23 + 0.1038800329*h1_24 + -0.2862158716*h1_25 + -0.1268335283*h1_26 + -0.0150441630*h1_27 + 0.0196202360*h1_28 + 0.2780441046*h1_29 + -0.1786803901*h1_30 + -0.0123723047*h1_31, 2));
        h2_13 = (0.2725050151 + -0.0606569648*h1_0 + -0.1282525063*h1_1 + 0.2068860680*h1_2 + -0.0490616113*h1_3 + -0.0156390704*h1_4 + -0.0640960783*h1_5 + -0.3468127847*h1_6 + -0.1542405635*h1_7 + -0.1655995995*h1_8 + 0.1094022244*h1_9 + -0.1103449464*h1_10 + 0.2739811540*h1_11 + 0.1426658332*h1_12 + 0.0605960786*h1_13 + 0.0795666128*h1_14 + 0.4548890293*h1_15 + 0.2001143247*h1_16 + 0.0166393556*h1_17 + -0.2059117407*h1_18 + 0.0097089233*h1_19 + -0.1238938868*h1_20 + -0.1009437814*h1_21 + -0.1144225299*h1_22 + 0.2479013801*h1_23 + 0.0824673921*h1_24 + 0.0527164973*h1_25 + -0.2057310492*h1_26 + -0.2486716956*h1_27 + -0.0311973337*h1_28 + -0.2215582579*h1_29 + -0.0934593976*h1_30 + 0.1103094593*h1_31) / sqrt(1 + pow(0.2725050151 + -0.0606569648*h1_0 + -0.1282525063*h1_1 + 0.2068860680*h1_2 + -0.0490616113*h1_3 + -0.0156390704*h1_4 + -0.0640960783*h1_5 + -0.3468127847*h1_6 + -0.1542405635*h1_7 + -0.1655995995*h1_8 + 0.1094022244*h1_9 + -0.1103449464*h1_10 + 0.2739811540*h1_11 + 0.1426658332*h1_12 + 0.0605960786*h1_13 + 0.0795666128*h1_14 + 0.4548890293*h1_15 + 0.2001143247*h1_16 + 0.0166393556*h1_17 + -0.2059117407*h1_18 + 0.0097089233*h1_19 + -0.1238938868*h1_20 + -0.1009437814*h1_21 + -0.1144225299*h1_22 + 0.2479013801*h1_23 + 0.0824673921*h1_24 + 0.0527164973*h1_25 + -0.2057310492*h1_26 + -0.2486716956*h1_27 + -0.0311973337*h1_28 + -0.2215582579*h1_29 + -0.0934593976*h1_30 + 0.1103094593*h1_31, 2));
        h2_14 = (0.1757154316 + -0.1251949370*h1_0 + 0.2603076398*h1_1 + 0.4567189217*h1_2 + 0.5246231556*h1_3 + 0.2353635430*h1_4 + 0.0144785047*h1_5 + 0.2960108221*h1_6 + -0.2051374912*h1_7 + 0.4287915528*h1_8 + 0.1258242726*h1_9 + -0.0133019639*h1_10 + 0.6515095234*h1_11 + -0.2373038530*h1_12 + 0.1216651946*h1_13 + 0.0874592215*h1_14 + 0.0218112338*h1_15 + 0.1613809168*h1_16 + -0.0928839147*h1_17 + 0.0256624687*h1_18 + 0.1446863413*h1_19 + -0.1891886294*h1_20 + -0.2362297326*h1_21 + -0.2839857340*h1_22 + 0.3688596785*h1_23 + -0.0555567406*h1_24 + 0.2326618880*h1_25 + 0.0353279449*h1_26 + 0.0824790671*h1_27 + -0.2084865868*h1_28 + 0.1582941264*h1_29 + 0.0701801777*h1_30 + 0.1033538952*h1_31) / sqrt(1 + pow(0.1757154316 + -0.1251949370*h1_0 + 0.2603076398*h1_1 + 0.4567189217*h1_2 + 0.5246231556*h1_3 + 0.2353635430*h1_4 + 0.0144785047*h1_5 + 0.2960108221*h1_6 + -0.2051374912*h1_7 + 0.4287915528*h1_8 + 0.1258242726*h1_9 + -0.0133019639*h1_10 + 0.6515095234*h1_11 + -0.2373038530*h1_12 + 0.1216651946*h1_13 + 0.0874592215*h1_14 + 0.0218112338*h1_15 + 0.1613809168*h1_16 + -0.0928839147*h1_17 + 0.0256624687*h1_18 + 0.1446863413*h1_19 + -0.1891886294*h1_20 + -0.2362297326*h1_21 + -0.2839857340*h1_22 + 0.3688596785*h1_23 + -0.0555567406*h1_24 + 0.2326618880*h1_25 + 0.0353279449*h1_26 + 0.0824790671*h1_27 + -0.2084865868*h1_28 + 0.1582941264*h1_29 + 0.0701801777*h1_30 + 0.1033538952*h1_31, 2));
        h2_15 = (-0.2089485526 + 0.4655084908*h1_0 + -0.7344470024*h1_1 + -0.4397546649*h1_2 + -0.5532780290*h1_3 + -0.4076615572*h1_4 + -0.0495681465*h1_5 + 0.7548342347*h1_6 + -0.0013804069*h1_7 + -0.4856341779*h1_8 + -0.2017675638*h1_9 + -0.1473268270*h1_10 + -0.5545860529*h1_11 + -0.0477882475*h1_12 + 0.2283990085*h1_13 + -0.1863880157*h1_14 + 0.3451759815*h1_15 + 0.2170441747*h1_16 + 0.3937438726*h1_17 + -0.0837837234*h1_18 + 0.1846369505*h1_19 + -0.0525944158*h1_20 + 0.2047580779*h1_21 + 0.7200365067*h1_22 + -0.1982492656*h1_23 + 0.2081878334*h1_24 + -0.1256816238*h1_25 + -0.0198542587*h1_26 + 0.0671134442*h1_27 + 0.1109405532*h1_28 + 0.2689404786*h1_29 + 0.1275656819*h1_30 + -0.1612501591*h1_31) / sqrt(1 + pow(-0.2089485526 + 0.4655084908*h1_0 + -0.7344470024*h1_1 + -0.4397546649*h1_2 + -0.5532780290*h1_3 + -0.4076615572*h1_4 + -0.0495681465*h1_5 + 0.7548342347*h1_6 + -0.0013804069*h1_7 + -0.4856341779*h1_8 + -0.2017675638*h1_9 + -0.1473268270*h1_10 + -0.5545860529*h1_11 + -0.0477882475*h1_12 + 0.2283990085*h1_13 + -0.1863880157*h1_14 + 0.3451759815*h1_15 + 0.2170441747*h1_16 + 0.3937438726*h1_17 + -0.0837837234*h1_18 + 0.1846369505*h1_19 + -0.0525944158*h1_20 + 0.2047580779*h1_21 + 0.7200365067*h1_22 + -0.1982492656*h1_23 + 0.2081878334*h1_24 + -0.1256816238*h1_25 + -0.0198542587*h1_26 + 0.0671134442*h1_27 + 0.1109405532*h1_28 + 0.2689404786*h1_29 + 0.1275656819*h1_30 + -0.1612501591*h1_31, 2));
        h2_16 = (0.0522732101 + -0.0712730139*h1_0 + -0.1747533232*h1_1 + -0.0490974747*h1_2 + -0.1982413083*h1_3 + 0.2360217273*h1_4 + -0.0137688424*h1_5 + -0.7879621387*h1_6 + -0.2211323082*h1_7 + 0.3873040080*h1_8 + 0.0907761455*h1_9 + 0.0412139557*h1_10 + 0.0606913678*h1_11 + -0.0452370904*h1_12 + 0.0447800830*h1_13 + 0.1648720056*h1_14 + -0.4631069005*h1_15 + -0.4657867551*h1_16 + 0.2862678766*h1_17 + 0.0362324268*h1_18 + -0.0031000327*h1_19 + -0.1952672303*h1_20 + -0.2171385288*h1_21 + -0.0190482251*h1_22 + 0.2057720721*h1_23 + -0.1160677820*h1_24 + -0.2123176008*h1_25 + 0.0612228513*h1_26 + -0.0967836678*h1_27 + 0.3273430765*h1_28 + 0.0697780028*h1_29 + -0.3962572217*h1_30 + 0.0044049774*h1_31) / sqrt(1 + pow(0.0522732101 + -0.0712730139*h1_0 + -0.1747533232*h1_1 + -0.0490974747*h1_2 + -0.1982413083*h1_3 + 0.2360217273*h1_4 + -0.0137688424*h1_5 + -0.7879621387*h1_6 + -0.2211323082*h1_7 + 0.3873040080*h1_8 + 0.0907761455*h1_9 + 0.0412139557*h1_10 + 0.0606913678*h1_11 + -0.0452370904*h1_12 + 0.0447800830*h1_13 + 0.1648720056*h1_14 + -0.4631069005*h1_15 + -0.4657867551*h1_16 + 0.2862678766*h1_17 + 0.0362324268*h1_18 + -0.0031000327*h1_19 + -0.1952672303*h1_20 + -0.2171385288*h1_21 + -0.0190482251*h1_22 + 0.2057720721*h1_23 + -0.1160677820*h1_24 + -0.2123176008*h1_25 + 0.0612228513*h1_26 + -0.0967836678*h1_27 + 0.3273430765*h1_28 + 0.0697780028*h1_29 + -0.3962572217*h1_30 + 0.0044049774*h1_31, 2));
        h2_17 = (0.1873565316 + -0.1357932836*h1_0 + -0.0868110210*h1_1 + 0.1575219929*h1_2 + -0.1148255169*h1_3 + 0.0732811093*h1_4 + -0.0008508717*h1_5 + 0.1554124355*h1_6 + 0.0809920132*h1_7 + 0.0391773358*h1_8 + 0.0536600463*h1_9 + 0.0457719341*h1_10 + -0.0168140978*h1_11 + -0.1024755016*h1_12 + -0.0878169313*h1_13 + 0.1006968766*h1_14 + 0.4767182767*h1_15 + 0.1093687415*h1_16 + -0.0312652066*h1_17 + 0.0112300329*h1_18 + -0.1634342074*h1_19 + 0.1519738883*h1_20 + -0.1466175169*h1_21 + -0.1253972948*h1_22 + 0.0724867433*h1_23 + 0.1138851270*h1_24 + -0.1172311082*h1_25 + -0.1584057957*h1_26 + -0.2569785416*h1_27 + 0.2089471668*h1_28 + -0.2124546170*h1_29 + 0.1191995069*h1_30 + 0.1220859513*h1_31) / sqrt(1 + pow(0.1873565316 + -0.1357932836*h1_0 + -0.0868110210*h1_1 + 0.1575219929*h1_2 + -0.1148255169*h1_3 + 0.0732811093*h1_4 + -0.0008508717*h1_5 + 0.1554124355*h1_6 + 0.0809920132*h1_7 + 0.0391773358*h1_8 + 0.0536600463*h1_9 + 0.0457719341*h1_10 + -0.0168140978*h1_11 + -0.1024755016*h1_12 + -0.0878169313*h1_13 + 0.1006968766*h1_14 + 0.4767182767*h1_15 + 0.1093687415*h1_16 + -0.0312652066*h1_17 + 0.0112300329*h1_18 + -0.1634342074*h1_19 + 0.1519738883*h1_20 + -0.1466175169*h1_21 + -0.1253972948*h1_22 + 0.0724867433*h1_23 + 0.1138851270*h1_24 + -0.1172311082*h1_25 + -0.1584057957*h1_26 + -0.2569785416*h1_27 + 0.2089471668*h1_28 + -0.2124546170*h1_29 + 0.1191995069*h1_30 + 0.1220859513*h1_31, 2));
        h2_18 = (0.0196957123 + -0.0799146965*h1_0 + 1.1996418238*h1_1 + 0.9704314470*h1_2 + 0.8349709511*h1_3 + 0.7202768922*h1_4 + 0.2287265956*h1_5 + 0.2828790247*h1_6 + -0.0016549077*h1_7 + 0.6997677088*h1_8 + 0.0078373449*h1_9 + 0.2678270042*h1_10 + 0.5948938131*h1_11 + -0.4929759502*h1_12 + -0.1743981838*h1_13 + 0.5919702649*h1_14 + 0.0818867162*h1_15 + -0.2510015368*h1_16 + 0.0356036760*h1_17 + 0.1737972796*h1_18 + -0.0125250928*h1_19 + -0.3294214606*h1_20 + -0.1659418046*h1_21 + -1.3827867508*h1_22 + 0.3400036097*h1_23 + -0.0969293937*h1_24 + 0.3190492392*h1_25 + -0.2573552132*h1_26 + 0.0174460951*h1_27 + -0.3253608048*h1_28 + -0.0036409134*h1_29 + -0.0660561621*h1_30 + -0.1082683057*h1_31) / sqrt(1 + pow(0.0196957123 + -0.0799146965*h1_0 + 1.1996418238*h1_1 + 0.9704314470*h1_2 + 0.8349709511*h1_3 + 0.7202768922*h1_4 + 0.2287265956*h1_5 + 0.2828790247*h1_6 + -0.0016549077*h1_7 + 0.6997677088*h1_8 + 0.0078373449*h1_9 + 0.2678270042*h1_10 + 0.5948938131*h1_11 + -0.4929759502*h1_12 + -0.1743981838*h1_13 + 0.5919702649*h1_14 + 0.0818867162*h1_15 + -0.2510015368*h1_16 + 0.0356036760*h1_17 + 0.1737972796*h1_18 + -0.0125250928*h1_19 + -0.3294214606*h1_20 + -0.1659418046*h1_21 + -1.3827867508*h1_22 + 0.3400036097*h1_23 + -0.0969293937*h1_24 + 0.3190492392*h1_25 + -0.2573552132*h1_26 + 0.0174460951*h1_27 + -0.3253608048*h1_28 + -0.0036409134*h1_29 + -0.0660561621*h1_30 + -0.1082683057*h1_31, 2));
        h2_19 = (0.2994344532 + -0.0566196702*h1_0 + 0.1774229854*h1_1 + 0.1090772599*h1_2 + 0.1274024695*h1_3 + 0.0415072441*h1_4 + 0.0718061551*h1_5 + 0.3277353346*h1_6 + -0.2566600144*h1_7 + 0.0047283559*h1_8 + 0.1750250161*h1_9 + -0.1833938956*h1_10 + 0.0377594829*h1_11 + -0.0689859241*h1_12 + -0.2853849530*h1_13 + 0.0039551496*h1_14 + 0.2309493273*h1_15 + -0.0684477910*h1_16 + -0.0020736540*h1_17 + -0.2776728570*h1_18 + -0.0580063500*h1_19 + 0.3383476138*h1_20 + -0.3510909677*h1_21 + 0.0116811981*h1_22 + 0.1226174235*h1_23 + 0.3045949638*h1_24 + 0.0914296582*h1_25 + -0.3037024736*h1_26 + -0.1379434168*h1_27 + -0.1233752295*h1_28 + -0.2432824969*h1_29 + 0.1483380049*h1_30 + 0.0510091968*h1_31) / sqrt(1 + pow(0.2994344532 + -0.0566196702*h1_0 + 0.1774229854*h1_1 + 0.1090772599*h1_2 + 0.1274024695*h1_3 + 0.0415072441*h1_4 + 0.0718061551*h1_5 + 0.3277353346*h1_6 + -0.2566600144*h1_7 + 0.0047283559*h1_8 + 0.1750250161*h1_9 + -0.1833938956*h1_10 + 0.0377594829*h1_11 + -0.0689859241*h1_12 + -0.2853849530*h1_13 + 0.0039551496*h1_14 + 0.2309493273*h1_15 + -0.0684477910*h1_16 + -0.0020736540*h1_17 + -0.2776728570*h1_18 + -0.0580063500*h1_19 + 0.3383476138*h1_20 + -0.3510909677*h1_21 + 0.0116811981*h1_22 + 0.1226174235*h1_23 + 0.3045949638*h1_24 + 0.0914296582*h1_25 + -0.3037024736*h1_26 + -0.1379434168*h1_27 + -0.1233752295*h1_28 + -0.2432824969*h1_29 + 0.1483380049*h1_30 + 0.0510091968*h1_31, 2));
        h2_20 = (-0.2455536425 + -0.2295081764*h1_0 + -0.2104023397*h1_1 + 0.0053591323*h1_2 + -0.0158268660*h1_3 + 0.2227728814*h1_4 + 0.1509924084*h1_5 + -0.6140255928*h1_6 + 0.0704419464*h1_7 + 0.0755563006*h1_8 + 0.1014707834*h1_9 + 0.0357328095*h1_10 + -0.3358558118*h1_11 + -0.0515872985*h1_12 + 0.1861373484*h1_13 + -0.0472293347*h1_14 + -0.3516316414*h1_15 + 0.0624327548*h1_16 + 0.0354548953*h1_17 + -0.0375234857*h1_18 + -0.1182828620*h1_19 + -0.0250848420*h1_20 + 0.2710171938*h1_21 + -0.0350484811*h1_22 + 0.0459612571*h1_23 + -0.1030401364*h1_24 + 0.1037881225*h1_25 + -0.0723916963*h1_26 + 0.0143458266*h1_27 + 0.0768089071*h1_28 + -0.1351805478*h1_29 + -0.0304014422*h1_30 + 0.1767037809*h1_31) / sqrt(1 + pow(-0.2455536425 + -0.2295081764*h1_0 + -0.2104023397*h1_1 + 0.0053591323*h1_2 + -0.0158268660*h1_3 + 0.2227728814*h1_4 + 0.1509924084*h1_5 + -0.6140255928*h1_6 + 0.0704419464*h1_7 + 0.0755563006*h1_8 + 0.1014707834*h1_9 + 0.0357328095*h1_10 + -0.3358558118*h1_11 + -0.0515872985*h1_12 + 0.1861373484*h1_13 + -0.0472293347*h1_14 + -0.3516316414*h1_15 + 0.0624327548*h1_16 + 0.0354548953*h1_17 + -0.0375234857*h1_18 + -0.1182828620*h1_19 + -0.0250848420*h1_20 + 0.2710171938*h1_21 + -0.0350484811*h1_22 + 0.0459612571*h1_23 + -0.1030401364*h1_24 + 0.1037881225*h1_25 + -0.0723916963*h1_26 + 0.0143458266*h1_27 + 0.0768089071*h1_28 + -0.1351805478*h1_29 + -0.0304014422*h1_30 + 0.1767037809*h1_31, 2));
        h2_21 = (0.1645321399 + -0.4319067597*h1_0 + -0.1349791437*h1_1 + 0.0227852650*h1_2 + -0.2507950962*h1_3 + 0.0453615598*h1_4 + 0.6550542116*h1_5 + -0.3286297917*h1_6 + -0.0629569367*h1_7 + -0.2755894065*h1_8 + 0.0603650548*h1_9 + -0.3925249577*h1_10 + 0.1619986296*h1_11 + 0.2843771577*h1_12 + -0.0211039577*h1_13 + 0.1147227809*h1_14 + 0.0920750722*h1_15 + 0.0117603717*h1_16 + -0.7165827751*h1_17 + -0.1016923636*h1_18 + 0.7151746154*h1_19 + 0.7628494501*h1_20 + -0.1414683461*h1_21 + 0.0801646933*h1_22 + 0.0013684966*h1_23 + 0.0118469317*h1_24 + 0.2396360785*h1_25 + -0.2406806201*h1_26 + 0.1676672548*h1_27 + -0.1403004527*h1_28 + -0.6814861298*h1_29 + 0.2598832846*h1_30 + 0.2369083315*h1_31) / sqrt(1 + pow(0.1645321399 + -0.4319067597*h1_0 + -0.1349791437*h1_1 + 0.0227852650*h1_2 + -0.2507950962*h1_3 + 0.0453615598*h1_4 + 0.6550542116*h1_5 + -0.3286297917*h1_6 + -0.0629569367*h1_7 + -0.2755894065*h1_8 + 0.0603650548*h1_9 + -0.3925249577*h1_10 + 0.1619986296*h1_11 + 0.2843771577*h1_12 + -0.0211039577*h1_13 + 0.1147227809*h1_14 + 0.0920750722*h1_15 + 0.0117603717*h1_16 + -0.7165827751*h1_17 + -0.1016923636*h1_18 + 0.7151746154*h1_19 + 0.7628494501*h1_20 + -0.1414683461*h1_21 + 0.0801646933*h1_22 + 0.0013684966*h1_23 + 0.0118469317*h1_24 + 0.2396360785*h1_25 + -0.2406806201*h1_26 + 0.1676672548*h1_27 + -0.1403004527*h1_28 + -0.6814861298*h1_29 + 0.2598832846*h1_30 + 0.2369083315*h1_31, 2));
        h2_22 = (-0.2083899677 + -0.0304572359*h1_0 + -0.0332811773*h1_1 + -0.1923142970*h1_2 + -0.0366236530*h1_3 + 0.0459532365*h1_4 + -0.1120580956*h1_5 + 0.1955316663*h1_6 + 0.0211505089*h1_7 + 0.0809888765*h1_8 + -0.0985770971*h1_9 + -0.1022664309*h1_10 + -0.1024253815*h1_11 + -0.1089403406*h1_12 + 0.1355576664*h1_13 + 0.2248559147*h1_14 + -0.3930686712*h1_15 + -0.0373324640*h1_16 + 0.1927234232*h1_17 + -0.0250629112*h1_18 + -0.2107968777*h1_19 + -0.0304865986*h1_20 + 0.2484458387*h1_21 + 0.0142517984*h1_22 + -0.1561184227*h1_23 + 0.0149728879*h1_24 + -0.1835641414*h1_25 + 0.1544129103*h1_26 + 0.0806564763*h1_27 + 0.1710357219*h1_28 + -0.0953620449*h1_29 + -0.1891064495*h1_30 + 0.0443882272*h1_31) / sqrt(1 + pow(-0.2083899677 + -0.0304572359*h1_0 + -0.0332811773*h1_1 + -0.1923142970*h1_2 + -0.0366236530*h1_3 + 0.0459532365*h1_4 + -0.1120580956*h1_5 + 0.1955316663*h1_6 + 0.0211505089*h1_7 + 0.0809888765*h1_8 + -0.0985770971*h1_9 + -0.1022664309*h1_10 + -0.1024253815*h1_11 + -0.1089403406*h1_12 + 0.1355576664*h1_13 + 0.2248559147*h1_14 + -0.3930686712*h1_15 + -0.0373324640*h1_16 + 0.1927234232*h1_17 + -0.0250629112*h1_18 + -0.2107968777*h1_19 + -0.0304865986*h1_20 + 0.2484458387*h1_21 + 0.0142517984*h1_22 + -0.1561184227*h1_23 + 0.0149728879*h1_24 + -0.1835641414*h1_25 + 0.1544129103*h1_26 + 0.0806564763*h1_27 + 0.1710357219*h1_28 + -0.0953620449*h1_29 + -0.1891064495*h1_30 + 0.0443882272*h1_31, 2));
        h2_23 = (-0.2370624840 + 0.0287506822*h1_0 + 0.0084346477*h1_1 + 0.2323536724*h1_2 + 0.0536071956*h1_3 + 0.0224426500*h1_4 + 0.0060490263*h1_5 + -0.0326361358*h1_6 + 0.0387639031*h1_7 + 0.1619125754*h1_8 + -0.1015074998*h1_9 + -0.0166530758*h1_10 + -0.1791539788*h1_11 + 0.1434527487*h1_12 + 0.0339474082*h1_13 + -0.0831789896*h1_14 + -0.4233052433*h1_15 + 0.0979888588*h1_16 + -0.0265021529*h1_17 + -0.0359415002*h1_18 + 0.1229952276*h1_19 + -0.0938445926*h1_20 + -0.0010593517*h1_21 + -0.1299498379*h1_22 + 0.0737917796*h1_23 + 0.0787976086*h1_24 + 0.0999616385*h1_25 + 0.2037910521*h1_26 + 0.3089800775*h1_27 + -0.1229180917*h1_28 + -0.0412991904*h1_29 + 0.0244584810*h1_30 + 0.1962544620*h1_31) / sqrt(1 + pow(-0.2370624840 + 0.0287506822*h1_0 + 0.0084346477*h1_1 + 0.2323536724*h1_2 + 0.0536071956*h1_3 + 0.0224426500*h1_4 + 0.0060490263*h1_5 + -0.0326361358*h1_6 + 0.0387639031*h1_7 + 0.1619125754*h1_8 + -0.1015074998*h1_9 + -0.0166530758*h1_10 + -0.1791539788*h1_11 + 0.1434527487*h1_12 + 0.0339474082*h1_13 + -0.0831789896*h1_14 + -0.4233052433*h1_15 + 0.0979888588*h1_16 + -0.0265021529*h1_17 + -0.0359415002*h1_18 + 0.1229952276*h1_19 + -0.0938445926*h1_20 + -0.0010593517*h1_21 + -0.1299498379*h1_22 + 0.0737917796*h1_23 + 0.0787976086*h1_24 + 0.0999616385*h1_25 + 0.2037910521*h1_26 + 0.3089800775*h1_27 + -0.1229180917*h1_28 + -0.0412991904*h1_29 + 0.0244584810*h1_30 + 0.1962544620*h1_31, 2));
        h2_24 = (-0.2851626575 + 0.0250820071*h1_0 + 0.0791278109*h1_1 + 0.0252211262*h1_2 + -0.1287650764*h1_3 + -0.1576977372*h1_4 + -0.3310686052*h1_5 + 0.0282159876*h1_6 + 0.1739916652*h1_7 + 0.0232867859*h1_8 + 0.0631389394*h1_9 + -0.0379345305*h1_10 + -0.0080883168*h1_11 + -0.2830593288*h1_12 + 0.1327938586*h1_13 + 0.1207627133*h1_14 + -0.3965930343*h1_15 + 0.1514226049*h1_16 + 0.1114440039*h1_17 + 0.3373610675*h1_18 + -0.1738334745*h1_19 + -0.1401947439*h1_20 + 0.3555114865*h1_21 + -0.1113037467*h1_22 + -0.0536033623*h1_23 + -0.0024254259*h1_24 + -0.2820398211*h1_25 + 0.2515229583*h1_26 + 0.0066224495*h1_27 + 0.3151710331*h1_28 + 0.0968119279*h1_29 + -0.1318698376*h1_30 + 0.0597883910*h1_31) / sqrt(1 + pow(-0.2851626575 + 0.0250820071*h1_0 + 0.0791278109*h1_1 + 0.0252211262*h1_2 + -0.1287650764*h1_3 + -0.1576977372*h1_4 + -0.3310686052*h1_5 + 0.0282159876*h1_6 + 0.1739916652*h1_7 + 0.0232867859*h1_8 + 0.0631389394*h1_9 + -0.0379345305*h1_10 + -0.0080883168*h1_11 + -0.2830593288*h1_12 + 0.1327938586*h1_13 + 0.1207627133*h1_14 + -0.3965930343*h1_15 + 0.1514226049*h1_16 + 0.1114440039*h1_17 + 0.3373610675*h1_18 + -0.1738334745*h1_19 + -0.1401947439*h1_20 + 0.3555114865*h1_21 + -0.1113037467*h1_22 + -0.0536033623*h1_23 + -0.0024254259*h1_24 + -0.2820398211*h1_25 + 0.2515229583*h1_26 + 0.0066224495*h1_27 + 0.3151710331*h1_28 + 0.0968119279*h1_29 + -0.1318698376*h1_30 + 0.0597883910*h1_31, 2));
        h2_25 = (-0.0410324335 + 1.8528696299*h1_0 + 0.2417572439*h1_1 + 0.1685038060*h1_2 + 0.2500019968*h1_3 + -0.1503233165*h1_4 + -1.6354031563*h1_5 + -0.1368062049*h1_6 + 0.2799278498*h1_7 + -0.1177713722*h1_8 + -0.1457748860*h1_9 + 1.0941104889*h1_10 + -0.1041855291*h1_11 + -0.6965174675*h1_12 + 0.3926788568*h1_13 + -0.0094093988*h1_14 + 2.6232202053*h1_15 + -0.0428552367*h1_16 + 1.8706686497*h1_17 + 0.6683984399*h1_18 + -1.1735421419*h1_19 + -1.5151289701*h1_20 + 0.0281199124*h1_21 + 0.0856724083*h1_22 + -0.2766703665*h1_23 + -0.1215381846*h1_24 + -0.6109527349*h1_25 + 0.4749423862*h1_26 + 0.2904486954*h1_27 + 0.2408998162*h1_28 + 2.5843460560*h1_29 + -0.2496728003*h1_30 + -1.2437283993*h1_31) / sqrt(1 + pow(-0.0410324335 + 1.8528696299*h1_0 + 0.2417572439*h1_1 + 0.1685038060*h1_2 + 0.2500019968*h1_3 + -0.1503233165*h1_4 + -1.6354031563*h1_5 + -0.1368062049*h1_6 + 0.2799278498*h1_7 + -0.1177713722*h1_8 + -0.1457748860*h1_9 + 1.0941104889*h1_10 + -0.1041855291*h1_11 + -0.6965174675*h1_12 + 0.3926788568*h1_13 + -0.0094093988*h1_14 + 2.6232202053*h1_15 + -0.0428552367*h1_16 + 1.8706686497*h1_17 + 0.6683984399*h1_18 + -1.1735421419*h1_19 + -1.5151289701*h1_20 + 0.0281199124*h1_21 + 0.0856724083*h1_22 + -0.2766703665*h1_23 + -0.1215381846*h1_24 + -0.6109527349*h1_25 + 0.4749423862*h1_26 + 0.2904486954*h1_27 + 0.2408998162*h1_28 + 2.5843460560*h1_29 + -0.2496728003*h1_30 + -1.2437283993*h1_31, 2));
        h2_26 = (-0.2584717870 + 2.1934227943*h1_0 + 0.0480133779*h1_1 + 0.2900738120*h1_2 + -0.3735225201*h1_3 + -0.0915341973*h1_4 + -1.7647916079*h1_5 + 1.3597480059*h1_6 + 0.2084438354*h1_7 + 0.0318924449*h1_8 + 0.0084626544*h1_9 + 1.2779290676*h1_10 + 0.0285267401*h1_11 + -0.5680024624*h1_12 + 0.3506689370*h1_13 + 0.1873412132*h1_14 + 2.7958762646*h1_15 + -0.2647392750*h1_16 + 1.6592487097*h1_17 + 0.7778780460*h1_18 + -1.3474025726*h1_19 + -1.6455720663*h1_20 + 0.2602781653*h1_21 + -0.0641834959*h1_22 + -0.0867133141*h1_23 + -0.2442851514*h1_24 + -0.9162144661*h1_25 + 0.4793148339*h1_26 + -0.1841597706*h1_27 + 0.5255194902*h1_28 + 2.3544418812*h1_29 + -0.6484757662*h1_30 + -1.7721202374*h1_31) / sqrt(1 + pow(-0.2584717870 + 2.1934227943*h1_0 + 0.0480133779*h1_1 + 0.2900738120*h1_2 + -0.3735225201*h1_3 + -0.0915341973*h1_4 + -1.7647916079*h1_5 + 1.3597480059*h1_6 + 0.2084438354*h1_7 + 0.0318924449*h1_8 + 0.0084626544*h1_9 + 1.2779290676*h1_10 + 0.0285267401*h1_11 + -0.5680024624*h1_12 + 0.3506689370*h1_13 + 0.1873412132*h1_14 + 2.7958762646*h1_15 + -0.2647392750*h1_16 + 1.6592487097*h1_17 + 0.7778780460*h1_18 + -1.3474025726*h1_19 + -1.6455720663*h1_20 + 0.2602781653*h1_21 + -0.0641834959*h1_22 + -0.0867133141*h1_23 + -0.2442851514*h1_24 + -0.9162144661*h1_25 + 0.4793148339*h1_26 + -0.1841597706*h1_27 + 0.5255194902*h1_28 + 2.3544418812*h1_29 + -0.6484757662*h1_30 + -1.7721202374*h1_31, 2));
        h2_27 = (0.3257012963 + -0.0187412519*h1_0 + -0.0409622490*h1_1 + 0.1456849575*h1_2 + 0.1206420287*h1_3 + 0.1741372049*h1_4 + -0.0198963247*h1_5 + -0.4970513880*h1_6 + -0.2790485024*h1_7 + -0.0689065307*h1_8 + 0.0265413392*h1_9 + -0.2507814765*h1_10 + 0.1863280982*h1_11 + 0.1942964494*h1_12 + -0.3145252764*h1_13 + -0.1728291661*h1_14 + 0.4258266091*h1_15 + 0.0136074964*h1_16 + -0.1700103730*h1_17 + -0.2542855442*h1_18 + 0.2248034775*h1_19 + 0.3289410174*h1_20 + -0.3003448248*h1_21 + 0.1653990597*h1_22 + 0.1415460855*h1_23 + 0.0131905535*h1_24 + -0.0622438192*h1_25 + -0.1564412117*h1_26 + -0.1085629463*h1_27 + -0.1839374304*h1_28 + 0.0042610820*h1_29 + -0.2020883113*h1_30 + -0.1079272851*h1_31) / sqrt(1 + pow(0.3257012963 + -0.0187412519*h1_0 + -0.0409622490*h1_1 + 0.1456849575*h1_2 + 0.1206420287*h1_3 + 0.1741372049*h1_4 + -0.0198963247*h1_5 + -0.4970513880*h1_6 + -0.2790485024*h1_7 + -0.0689065307*h1_8 + 0.0265413392*h1_9 + -0.2507814765*h1_10 + 0.1863280982*h1_11 + 0.1942964494*h1_12 + -0.3145252764*h1_13 + -0.1728291661*h1_14 + 0.4258266091*h1_15 + 0.0136074964*h1_16 + -0.1700103730*h1_17 + -0.2542855442*h1_18 + 0.2248034775*h1_19 + 0.3289410174*h1_20 + -0.3003448248*h1_21 + 0.1653990597*h1_22 + 0.1415460855*h1_23 + 0.0131905535*h1_24 + -0.0622438192*h1_25 + -0.1564412117*h1_26 + -0.1085629463*h1_27 + -0.1839374304*h1_28 + 0.0042610820*h1_29 + -0.2020883113*h1_30 + -0.1079272851*h1_31, 2));
        h2_28 = (-0.2416312844 + -0.1339494884*h1_0 + 0.1047833934*h1_1 + 0.0624288879*h1_2 + 0.0275755432*h1_3 + 0.3091086149*h1_4 + -0.1501329094*h1_5 + 0.2005196512*h1_6 + -0.0618660413*h1_7 + 0.0052649663*h1_8 + -0.1769968718*h1_9 + -0.1025706157*h1_10 + -0.1652757078*h1_11 + 0.1041898951*h1_12 + 0.0191009026*h1_13 + 0.1604256779*h1_14 + -0.5536454320*h1_15 + 0.0164628420*h1_16 + 0.0168578792*h1_17 + 0.1484330148*h1_18 + -0.0147761330*h1_19 + 0.1499132067*h1_20 + 0.1288132519*h1_21 + 0.0850286260*h1_22 + 0.1327296495*h1_23 + 0.0270583052*h1_24 + 0.0662111714*h1_25 + -0.0560906306*h1_26 + 0.1800273508*h1_27 + 0.1266779006*h1_28 + -0.0053363829*h1_29 + 0.2028326094*h1_30 + 0.0209504701*h1_31) / sqrt(1 + pow(-0.2416312844 + -0.1339494884*h1_0 + 0.1047833934*h1_1 + 0.0624288879*h1_2 + 0.0275755432*h1_3 + 0.3091086149*h1_4 + -0.1501329094*h1_5 + 0.2005196512*h1_6 + -0.0618660413*h1_7 + 0.0052649663*h1_8 + -0.1769968718*h1_9 + -0.1025706157*h1_10 + -0.1652757078*h1_11 + 0.1041898951*h1_12 + 0.0191009026*h1_13 + 0.1604256779*h1_14 + -0.5536454320*h1_15 + 0.0164628420*h1_16 + 0.0168578792*h1_17 + 0.1484330148*h1_18 + -0.0147761330*h1_19 + 0.1499132067*h1_20 + 0.1288132519*h1_21 + 0.0850286260*h1_22 + 0.1327296495*h1_23 + 0.0270583052*h1_24 + 0.0662111714*h1_25 + -0.0560906306*h1_26 + 0.1800273508*h1_27 + 0.1266779006*h1_28 + -0.0053363829*h1_29 + 0.2028326094*h1_30 + 0.0209504701*h1_31, 2));
        h2_29 = (0.2556332648 + 0.0728335232*h1_0 + 0.0199137777*h1_1 + -0.0873163790*h1_2 + -0.1071822643*h1_3 + -0.2014494240*h1_4 + 0.0138172535*h1_5 + -0.2600414753*h1_6 + -0.1504397392*h1_7 + 0.0134406853*h1_8 + -0.1299866736*h1_9 + -0.0200552754*h1_10 + 0.0411080346*h1_11 + 0.0259383116*h1_12 + 0.0133491112*h1_13 + -0.0994323045*h1_14 + 0.5509539843*h1_15 + -0.0946255475*h1_16 + -0.1619859785*h1_17 + -0.0847335458*h1_18 + 0.0539320633*h1_19 + 0.0234917942*h1_20 + -0.0874277800*h1_21 + -0.1388886720*h1_22 + 0.1230067760*h1_23 + 0.0900382698*h1_24 + -0.2557844222*h1_25 + -0.0701770261*h1_26 + -0.1721774638*h1_27 + -0.0971151292*h1_28 + -0.1490623504*h1_29 + -0.2843458652*h1_30 + 0.0839865953*h1_31) / sqrt(1 + pow(0.2556332648 + 0.0728335232*h1_0 + 0.0199137777*h1_1 + -0.0873163790*h1_2 + -0.1071822643*h1_3 + -0.2014494240*h1_4 + 0.0138172535*h1_5 + -0.2600414753*h1_6 + -0.1504397392*h1_7 + 0.0134406853*h1_8 + -0.1299866736*h1_9 + -0.0200552754*h1_10 + 0.0411080346*h1_11 + 0.0259383116*h1_12 + 0.0133491112*h1_13 + -0.0994323045*h1_14 + 0.5509539843*h1_15 + -0.0946255475*h1_16 + -0.1619859785*h1_17 + -0.0847335458*h1_18 + 0.0539320633*h1_19 + 0.0234917942*h1_20 + -0.0874277800*h1_21 + -0.1388886720*h1_22 + 0.1230067760*h1_23 + 0.0900382698*h1_24 + -0.2557844222*h1_25 + -0.0701770261*h1_26 + -0.1721774638*h1_27 + -0.0971151292*h1_28 + -0.1490623504*h1_29 + -0.2843458652*h1_30 + 0.0839865953*h1_31, 2));
        h2_30 = (-0.1345360428 + -0.0793619081*h1_0 + 0.0950723663*h1_1 + -0.2510099113*h1_2 + -0.1421504021*h1_3 + -0.1505044997*h1_4 + -0.0638635829*h1_5 + 0.2880983651*h1_6 + 0.0791421682*h1_7 + -0.1830279231*h1_8 + 0.0336906351*h1_9 + 0.1598399878*h1_10 + -0.1415509433*h1_11 + 0.1367783546*h1_12 + 0.0978421271*h1_13 + -0.0958172753*h1_14 + -0.5007184744*h1_15 + 0.1206236258*h1_16 + -0.0675736442*h1_17 + -0.2420113832*h1_18 + 0.0270815305*h1_19 + -0.0047967071*h1_20 + 0.1612903178*h1_21 + 0.1019224897*h1_22 + 0.0377779603*h1_23 + 0.1070543006*h1_24 + -0.0859865397*h1_25 + 0.0455491841*h1_26 + -0.0521197356*h1_27 + -0.1865483820*h1_28 + 0.1793666184*h1_29 + -0.0519205332*h1_30 + 0.1444111913*h1_31) / sqrt(1 + pow(-0.1345360428 + -0.0793619081*h1_0 + 0.0950723663*h1_1 + -0.2510099113*h1_2 + -0.1421504021*h1_3 + -0.1505044997*h1_4 + -0.0638635829*h1_5 + 0.2880983651*h1_6 + 0.0791421682*h1_7 + -0.1830279231*h1_8 + 0.0336906351*h1_9 + 0.1598399878*h1_10 + -0.1415509433*h1_11 + 0.1367783546*h1_12 + 0.0978421271*h1_13 + -0.0958172753*h1_14 + -0.5007184744*h1_15 + 0.1206236258*h1_16 + -0.0675736442*h1_17 + -0.2420113832*h1_18 + 0.0270815305*h1_19 + -0.0047967071*h1_20 + 0.1612903178*h1_21 + 0.1019224897*h1_22 + 0.0377779603*h1_23 + 0.1070543006*h1_24 + -0.0859865397*h1_25 + 0.0455491841*h1_26 + -0.0521197356*h1_27 + -0.1865483820*h1_28 + 0.1793666184*h1_29 + -0.0519205332*h1_30 + 0.1444111913*h1_31, 2));
        h2_31 = (0.2711646855 + -0.2923828661*h1_0 + 0.1814143956*h1_1 + 0.1699660867*h1_2 + -0.1428333968*h1_3 + 0.1117714942*h1_4 + 0.0434265994*h1_5 + -0.3256760836*h1_6 + 0.0682410225*h1_7 + 0.1488262564*h1_8 + 0.1049271971*h1_9 + -0.2461149693*h1_10 + -0.0143220983*h1_11 + -0.1200167239*h1_12 + -0.0445608310*h1_13 + 0.1171977073*h1_14 + 0.2581152916*h1_15 + 0.1747310162*h1_16 + 0.0105529064*h1_17 + -0.1123794392*h1_18 + 0.2911168039*h1_19 + 0.0561579093*h1_20 + -0.0099273492*h1_21 + 0.0974639654*h1_22 + -0.1749938726*h1_23 + -0.0457602106*h1_24 + 0.0825244859*h1_25 + -0.0604328997*h1_26 + -0.2745197415*h1_27 + -0.2093826532*h1_28 + -0.0934310034*h1_29 + -0.0431590378*h1_30 + -0.0077649569*h1_31) / sqrt(1 + pow(0.2711646855 + -0.2923828661*h1_0 + 0.1814143956*h1_1 + 0.1699660867*h1_2 + -0.1428333968*h1_3 + 0.1117714942*h1_4 + 0.0434265994*h1_5 + -0.3256760836*h1_6 + 0.0682410225*h1_7 + 0.1488262564*h1_8 + 0.1049271971*h1_9 + -0.2461149693*h1_10 + -0.0143220983*h1_11 + -0.1200167239*h1_12 + -0.0445608310*h1_13 + 0.1171977073*h1_14 + 0.2581152916*h1_15 + 0.1747310162*h1_16 + 0.0105529064*h1_17 + -0.1123794392*h1_18 + 0.2911168039*h1_19 + 0.0561579093*h1_20 + -0.0099273492*h1_21 + 0.0974639654*h1_22 + -0.1749938726*h1_23 + -0.0457602106*h1_24 + 0.0825244859*h1_25 + -0.0604328997*h1_26 + -0.2745197415*h1_27 + -0.2093826532*h1_28 + -0.0934310034*h1_29 + -0.0431590378*h1_30 + -0.0077649569*h1_31, 2));

        // Hidden Layer 3: 32 -> 32 ISRU

        h3_0 = (0.2864945531 + 0.0613633096*h2_0 + -0.1884658337*h2_1 + 0.2105958611*h2_2 + 0.0905191377*h2_3 + -0.2053629905*h2_4 + 0.2923339307*h2_5 + -0.1654830873*h2_6 + 0.0577003546*h2_7 + -0.3334258497*h2_8 + -0.1705022752*h2_9 + -0.2239124179*h2_10 + 0.7856085896*h2_11 + -0.1258365065*h2_12 + 0.3502791524*h2_13 + -0.1633127183*h2_14 + -0.1428336501*h2_15 + -0.2837122977*h2_16 + -0.0748041421*h2_17 + 0.0041522579*h2_18 + -0.0291079395*h2_19 + -0.2314931154*h2_20 + 0.1938143969*h2_21 + -0.1328994632*h2_22 + -0.0807084069*h2_23 + -0.2936628759*h2_24 + 0.3895507157*h2_25 + -0.9466532469*h2_26 + 0.6167808175*h2_27 + -0.0817194432*h2_28 + 0.4880441129*h2_29 + -0.1249785647*h2_30 + 0.3840324879*h2_31) / sqrt(1 + pow(0.2864945531 + 0.0613633096*h2_0 + -0.1884658337*h2_1 + 0.2105958611*h2_2 + 0.0905191377*h2_3 + -0.2053629905*h2_4 + 0.2923339307*h2_5 + -0.1654830873*h2_6 + 0.0577003546*h2_7 + -0.3334258497*h2_8 + -0.1705022752*h2_9 + -0.2239124179*h2_10 + 0.7856085896*h2_11 + -0.1258365065*h2_12 + 0.3502791524*h2_13 + -0.1633127183*h2_14 + -0.1428336501*h2_15 + -0.2837122977*h2_16 + -0.0748041421*h2_17 + 0.0041522579*h2_18 + -0.0291079395*h2_19 + -0.2314931154*h2_20 + 0.1938143969*h2_21 + -0.1328994632*h2_22 + -0.0807084069*h2_23 + -0.2936628759*h2_24 + 0.3895507157*h2_25 + -0.9466532469*h2_26 + 0.6167808175*h2_27 + -0.0817194432*h2_28 + 0.4880441129*h2_29 + -0.1249785647*h2_30 + 0.3840324879*h2_31, 2));
        h3_1 = (0.2944185734 + -0.2102841586*h2_0 + -0.2316978574*h2_1 + -0.0982668474*h2_2 + 0.2331442982*h2_3 + -0.3994461894*h2_4 + 0.3149972856*h2_5 + -0.4536579251*h2_6 + 0.3083737493*h2_7 + -0.1974924952*h2_8 + -0.1082195267*h2_9 + -0.1518116444*h2_10 + 1.0786408186*h2_11 + -0.4413440824*h2_12 + 0.1732558906*h2_13 + 0.0899693817*h2_14 + -0.1778733581*h2_15 + -0.2542321384*h2_16 + -0.0525891371*h2_17 + -0.1459282190*h2_18 + 0.2400686592*h2_19 + 0.1385868788*h2_20 + 0.4261723757*h2_21 + -0.1269176602*h2_22 + -0.2046485096*h2_23 + -0.3931651413*h2_24 + 0.6747787595*h2_25 + -1.0883859396*h2_26 + 0.3521989584*h2_27 + -0.3722109199*h2_28 + 0.3486810029*h2_29 + -0.1277900189*h2_30 + 0.1516747177*h2_31) / sqrt(1 + pow(0.2944185734 + -0.2102841586*h2_0 + -0.2316978574*h2_1 + -0.0982668474*h2_2 + 0.2331442982*h2_3 + -0.3994461894*h2_4 + 0.3149972856*h2_5 + -0.4536579251*h2_6 + 0.3083737493*h2_7 + -0.1974924952*h2_8 + -0.1082195267*h2_9 + -0.1518116444*h2_10 + 1.0786408186*h2_11 + -0.4413440824*h2_12 + 0.1732558906*h2_13 + 0.0899693817*h2_14 + -0.1778733581*h2_15 + -0.2542321384*h2_16 + -0.0525891371*h2_17 + -0.1459282190*h2_18 + 0.2400686592*h2_19 + 0.1385868788*h2_20 + 0.4261723757*h2_21 + -0.1269176602*h2_22 + -0.2046485096*h2_23 + -0.3931651413*h2_24 + 0.6747787595*h2_25 + -1.0883859396*h2_26 + 0.3521989584*h2_27 + -0.3722109199*h2_28 + 0.3486810029*h2_29 + -0.1277900189*h2_30 + 0.1516747177*h2_31, 2));
        h3_2 = (0.2589806020 + 0.0700296685*h2_0 + -0.3980566561*h2_1 + 0.0870135874*h2_2 + 0.1963844001*h2_3 + -0.2413691729*h2_4 + 0.3408683538*h2_5 + -0.2962603569*h2_6 + 0.3535356224*h2_7 + -0.5647217631*h2_8 + -0.4522195458*h2_9 + -0.1408219784*h2_10 + 2.1042056084*h2_11 + -0.2273835987*h2_12 + 0.6455754042*h2_13 + -0.1173361838*h2_14 + -0.2885420620*h2_15 + 0.1689586788*h2_16 + 0.1702105403*h2_17 + -0.1373427659*h2_18 + -0.0757840946*h2_19 + 0.1438689530*h2_20 + 0.2404512614*h2_21 + -0.1990729123*h2_22 + 0.0507326350*h2_23 + -0.2751751542*h2_24 + 1.0030493736*h2_25 + -1.7609964609*h2_26 + 0.9959635735*h2_27 + -0.2871312797*h2_28 + 0.9540464878*h2_29 + -0.1210309416*h2_30 + 0.3021731377*h2_31) / sqrt(1 + pow(0.2589806020 + 0.0700296685*h2_0 + -0.3980566561*h2_1 + 0.0870135874*h2_2 + 0.1963844001*h2_3 + -0.2413691729*h2_4 + 0.3408683538*h2_5 + -0.2962603569*h2_6 + 0.3535356224*h2_7 + -0.5647217631*h2_8 + -0.4522195458*h2_9 + -0.1408219784*h2_10 + 2.1042056084*h2_11 + -0.2273835987*h2_12 + 0.6455754042*h2_13 + -0.1173361838*h2_14 + -0.2885420620*h2_15 + 0.1689586788*h2_16 + 0.1702105403*h2_17 + -0.1373427659*h2_18 + -0.0757840946*h2_19 + 0.1438689530*h2_20 + 0.2404512614*h2_21 + -0.1990729123*h2_22 + 0.0507326350*h2_23 + -0.2751751542*h2_24 + 1.0030493736*h2_25 + -1.7609964609*h2_26 + 0.9959635735*h2_27 + -0.2871312797*h2_28 + 0.9540464878*h2_29 + -0.1210309416*h2_30 + 0.3021731377*h2_31, 2));
        h3_3 = (0.2153141052 + -0.0312999524*h2_0 + -0.4008325934*h2_1 + -0.3119246662*h2_2 + 0.1956335902*h2_3 + -0.1666004956*h2_4 + 0.0913393795*h2_5 + -0.2927445769*h2_6 + 0.1039064452*h2_7 + -0.1444827616*h2_8 + -0.3378479779*h2_9 + -0.0695237592*h2_10 + 0.3355004191*h2_11 + -0.1914023161*h2_12 + -0.0763329268*h2_13 + 0.0859654248*h2_14 + -0.1736123115*h2_15 + -0.0662350506*h2_16 + 0.1423627436*h2_17 + -0.3617424667*h2_18 + 0.2508949041*h2_19 + 0.0322527625*h2_20 + -0.0312952176*h2_21 + -0.0170349907*h2_22 + 0.0650072247*h2_23 + 0.1121847034*h2_24 + 0.5257092714*h2_25 + -0.4859407246*h2_26 + -0.1286415905*h2_27 + -0.1696054786*h2_28 + 0.1031094119*h2_29 + -0.0308483802*h2_30 + -0.0306435749*h2_31) / sqrt(1 + pow(0.2153141052 + -0.0312999524*h2_0 + -0.4008325934*h2_1 + -0.3119246662*h2_2 + 0.1956335902*h2_3 + -0.1666004956*h2_4 + 0.0913393795*h2_5 + -0.2927445769*h2_6 + 0.1039064452*h2_7 + -0.1444827616*h2_8 + -0.3378479779*h2_9 + -0.0695237592*h2_10 + 0.3355004191*h2_11 + -0.1914023161*h2_12 + -0.0763329268*h2_13 + 0.0859654248*h2_14 + -0.1736123115*h2_15 + -0.0662350506*h2_16 + 0.1423627436*h2_17 + -0.3617424667*h2_18 + 0.2508949041*h2_19 + 0.0322527625*h2_20 + -0.0312952176*h2_21 + -0.0170349907*h2_22 + 0.0650072247*h2_23 + 0.1121847034*h2_24 + 0.5257092714*h2_25 + -0.4859407246*h2_26 + -0.1286415905*h2_27 + -0.1696054786*h2_28 + 0.1031094119*h2_29 + -0.0308483802*h2_30 + -0.0306435749*h2_31, 2));
        h3_4 = (0.1835415363 + 0.2868377864*h2_0 + -0.8067197204*h2_1 + -0.5006032586*h2_2 + -0.1702218652*h2_3 + -0.3257820010*h2_4 + 0.3131347895*h2_5 + -0.0782486498*h2_6 + 0.0282730851*h2_7 + -0.1901427805*h2_8 + -0.3678615391*h2_9 + -0.3219963312*h2_10 + 1.2439637184*h2_11 + -0.0282288976*h2_12 + 0.2795590758*h2_13 + -0.1924522668*h2_14 + -0.0742694363*h2_15 + -0.1107336208*h2_16 + 0.2493667156*h2_17 + -0.6237819195*h2_18 + 0.1332948655*h2_19 + -0.0929771066*h2_20 + 0.2070400119*h2_21 + 0.0570180677*h2_22 + -0.1388906986*h2_23 + -0.3574926257*h2_24 + 0.8215443492*h2_25 + -0.1149742976*h2_26 + 0.2178803682*h2_27 + -0.4665376246*h2_28 + 0.7587559819*h2_29 + 0.0919485837*h2_30 + -0.1173619255*h2_31) / sqrt(1 + pow(0.1835415363 + 0.2868377864*h2_0 + -0.8067197204*h2_1 + -0.5006032586*h2_2 + -0.1702218652*h2_3 + -0.3257820010*h2_4 + 0.3131347895*h2_5 + -0.0782486498*h2_6 + 0.0282730851*h2_7 + -0.1901427805*h2_8 + -0.3678615391*h2_9 + -0.3219963312*h2_10 + 1.2439637184*h2_11 + -0.0282288976*h2_12 + 0.2795590758*h2_13 + -0.1924522668*h2_14 + -0.0742694363*h2_15 + -0.1107336208*h2_16 + 0.2493667156*h2_17 + -0.6237819195*h2_18 + 0.1332948655*h2_19 + -0.0929771066*h2_20 + 0.2070400119*h2_21 + 0.0570180677*h2_22 + -0.1388906986*h2_23 + -0.3574926257*h2_24 + 0.8215443492*h2_25 + -0.1149742976*h2_26 + 0.2178803682*h2_27 + -0.4665376246*h2_28 + 0.7587559819*h2_29 + 0.0919485837*h2_30 + -0.1173619255*h2_31, 2));
        h3_5 = (0.2681034207 + -0.2046379298*h2_0 + -0.3319504857*h2_1 + -0.0110394917*h2_2 + -0.6671770215*h2_3 + 0.0485158674*h2_4 + -0.2004623860*h2_5 + 0.0673629642*h2_6 + 0.1848930717*h2_7 + 0.5756151676*h2_8 + 0.2630991340*h2_9 + 0.2161304802*h2_10 + -1.4836976528*h2_11 + 0.3596211076*h2_12 + -0.4712411761*h2_13 + 0.1144766286*h2_14 + 0.0994968489*h2_15 + 0.0297040492*h2_16 + 0.0871536881*h2_17 + 0.1823038906*h2_18 + 0.3751212358*h2_19 + -0.7148807645*h2_20 + -0.6694211960*h2_21 + 0.2456552088*h2_22 + -0.2785200179*h2_23 + -0.1189227328*h2_24 + 0.1540530175*h2_25 + 1.0144844055*h2_26 + -0.3120840490*h2_27 + 0.0514275543*h2_28 + -0.1427871585*h2_29 + 0.2840047181*h2_30 + -0.4547079802*h2_31) / sqrt(1 + pow(0.2681034207 + -0.2046379298*h2_0 + -0.3319504857*h2_1 + -0.0110394917*h2_2 + -0.6671770215*h2_3 + 0.0485158674*h2_4 + -0.2004623860*h2_5 + 0.0673629642*h2_6 + 0.1848930717*h2_7 + 0.5756151676*h2_8 + 0.2630991340*h2_9 + 0.2161304802*h2_10 + -1.4836976528*h2_11 + 0.3596211076*h2_12 + -0.4712411761*h2_13 + 0.1144766286*h2_14 + 0.0994968489*h2_15 + 0.0297040492*h2_16 + 0.0871536881*h2_17 + 0.1823038906*h2_18 + 0.3751212358*h2_19 + -0.7148807645*h2_20 + -0.6694211960*h2_21 + 0.2456552088*h2_22 + -0.2785200179*h2_23 + -0.1189227328*h2_24 + 0.1540530175*h2_25 + 1.0144844055*h2_26 + -0.3120840490*h2_27 + 0.0514275543*h2_28 + -0.1427871585*h2_29 + 0.2840047181*h2_30 + -0.4547079802*h2_31, 2));
        h3_6 = (-0.1551088542 + 0.2135570943*h2_0 + -0.2507204711*h2_1 + -0.5933983922*h2_2 + 0.2128743082*h2_3 + 0.0663581863*h2_4 + 0.0458404645*h2_5 + -0.1320265681*h2_6 + -0.0805951059*h2_7 + 0.0605032928*h2_8 + 0.0968060717*h2_9 + -0.2814170420*h2_10 + -0.2311169654*h2_11 + 0.1918138117*h2_12 + -0.2811278403*h2_13 + -0.5634851456*h2_14 + 0.4605693221*h2_15 + -0.1562473029*h2_16 + 0.0832574219*h2_17 + -0.4312146604*h2_18 + -0.1479389369*h2_19 + -0.0260566548*h2_20 + 0.1599405408*h2_21 + 0.1019731387*h2_22 + 0.0090046264*h2_23 + -0.0322467685*h2_24 + -0.3249422312*h2_25 + 0.0787208676*h2_26 + -0.1423161477*h2_27 + -0.0803640783*h2_28 + 0.0523795038*h2_29 + 0.5103963017*h2_30 + -0.0632616580*h2_31) / sqrt(1 + pow(-0.1551088542 + 0.2135570943*h2_0 + -0.2507204711*h2_1 + -0.5933983922*h2_2 + 0.2128743082*h2_3 + 0.0663581863*h2_4 + 0.0458404645*h2_5 + -0.1320265681*h2_6 + -0.0805951059*h2_7 + 0.0605032928*h2_8 + 0.0968060717*h2_9 + -0.2814170420*h2_10 + -0.2311169654*h2_11 + 0.1918138117*h2_12 + -0.2811278403*h2_13 + -0.5634851456*h2_14 + 0.4605693221*h2_15 + -0.1562473029*h2_16 + 0.0832574219*h2_17 + -0.4312146604*h2_18 + -0.1479389369*h2_19 + -0.0260566548*h2_20 + 0.1599405408*h2_21 + 0.1019731387*h2_22 + 0.0090046264*h2_23 + -0.0322467685*h2_24 + -0.3249422312*h2_25 + 0.0787208676*h2_26 + -0.1423161477*h2_27 + -0.0803640783*h2_28 + 0.0523795038*h2_29 + 0.5103963017*h2_30 + -0.0632616580*h2_31, 2));
        h3_7 = (-0.3485977054 + -0.0481825396*h2_0 + 0.1284174770*h2_1 + -0.0409315452*h2_2 + -0.2865156233*h2_3 + 0.2626012564*h2_4 + -0.1398671418*h2_5 + 0.3943447173*h2_6 + -0.0540271588*h2_7 + 0.3289100826*h2_8 + 0.2316204756*h2_9 + -0.0558242351*h2_10 + -0.9380410314*h2_11 + 0.4158063531*h2_12 + -0.2354305536*h2_13 + -0.0859479085*h2_14 + 0.1996767521*h2_15 + 0.1241840720*h2_16 + 0.1013574153*h2_17 + 0.0971378759*h2_18 + -0.0089241071*h2_19 + 0.2079940289*h2_20 + -0.1621641517*h2_21 + 0.3284215629*h2_22 + 0.1681687087*h2_23 + 0.2621742487*h2_24 + -0.4614519179*h2_25 + 0.9381286502*h2_26 + -0.4964101911*h2_27 + 0.3617733717*h2_28 + -0.5669314265*h2_29 + 0.1823033094*h2_30 + -0.0972281471*h2_31) / sqrt(1 + pow(-0.3485977054 + -0.0481825396*h2_0 + 0.1284174770*h2_1 + -0.0409315452*h2_2 + -0.2865156233*h2_3 + 0.2626012564*h2_4 + -0.1398671418*h2_5 + 0.3943447173*h2_6 + -0.0540271588*h2_7 + 0.3289100826*h2_8 + 0.2316204756*h2_9 + -0.0558242351*h2_10 + -0.9380410314*h2_11 + 0.4158063531*h2_12 + -0.2354305536*h2_13 + -0.0859479085*h2_14 + 0.1996767521*h2_15 + 0.1241840720*h2_16 + 0.1013574153*h2_17 + 0.0971378759*h2_18 + -0.0089241071*h2_19 + 0.2079940289*h2_20 + -0.1621641517*h2_21 + 0.3284215629*h2_22 + 0.1681687087*h2_23 + 0.2621742487*h2_24 + -0.4614519179*h2_25 + 0.9381286502*h2_26 + -0.4964101911*h2_27 + 0.3617733717*h2_28 + -0.5669314265*h2_29 + 0.1823033094*h2_30 + -0.0972281471*h2_31, 2));
        h3_8 = (0.2961162329 + 0.0798012689*h2_0 + -0.2441808134*h2_1 + 0.1241810247*h2_2 + 0.2607983947*h2_3 + -0.3527626991*h2_4 + 0.4773874283*h2_5 + -0.4661415815*h2_6 + 0.2168296278*h2_7 + -0.6287159920*h2_8 + -0.1292318851*h2_9 + -0.0845416635*h2_10 + 1.7558208704*h2_11 + -0.4884671569*h2_12 + 0.2804652154*h2_13 + -0.1365474612*h2_14 + -0.3638921678*h2_15 + 0.1010713279*h2_16 + 0.1048906893*h2_17 + -0.2154938728*h2_18 + 0.2796943784*h2_19 + 0.1931891888*h2_20 + 0.2563421428*h2_21 + -0.3465986848*h2_22 + -0.0161371585*h2_23 + -0.3733146489*h2_24 + 0.7788937688*h2_25 + -1.3258994818*h2_26 + 0.8231818676*h2_27 + -0.5078048706*h2_28 + 0.7393972278*h2_29 + -0.3093688190*h2_30 + 0.2417288870*h2_31) / sqrt(1 + pow(0.2961162329 + 0.0798012689*h2_0 + -0.2441808134*h2_1 + 0.1241810247*h2_2 + 0.2607983947*h2_3 + -0.3527626991*h2_4 + 0.4773874283*h2_5 + -0.4661415815*h2_6 + 0.2168296278*h2_7 + -0.6287159920*h2_8 + -0.1292318851*h2_9 + -0.0845416635*h2_10 + 1.7558208704*h2_11 + -0.4884671569*h2_12 + 0.2804652154*h2_13 + -0.1365474612*h2_14 + -0.3638921678*h2_15 + 0.1010713279*h2_16 + 0.1048906893*h2_17 + -0.2154938728*h2_18 + 0.2796943784*h2_19 + 0.1931891888*h2_20 + 0.2563421428*h2_21 + -0.3465986848*h2_22 + -0.0161371585*h2_23 + -0.3733146489*h2_24 + 0.7788937688*h2_25 + -1.3258994818*h2_26 + 0.8231818676*h2_27 + -0.5078048706*h2_28 + 0.7393972278*h2_29 + -0.3093688190*h2_30 + 0.2417288870*h2_31, 2));
        h3_9 = (0.2899270356 + -0.0638937205*h2_0 + -0.4068942666*h2_1 + 0.1672300845*h2_2 + 0.1256325990*h2_3 + -0.2099651843*h2_4 + 0.3948958218*h2_5 + -0.1849565357*h2_6 + 0.1376580745*h2_7 + -0.4319192469*h2_8 + -0.1920379996*h2_9 + -0.0246361662*h2_10 + 1.2337454557*h2_11 + -0.4566627741*h2_12 + 0.3912526369*h2_13 + 0.0972468555*h2_14 + -0.2816746235*h2_15 + -0.0321937576*h2_16 + 0.0020162477*h2_17 + -0.3856804371*h2_18 + -0.0190239120*h2_19 + 0.1675126404*h2_20 + 0.4877643585*h2_21 + -0.2383364439*h2_22 + -0.0834619105*h2_23 + -0.3586616516*h2_24 + 0.8997672796*h2_25 + -1.6043225527*h2_26 + 0.4792380929*h2_27 + -0.4394580722*h2_28 + 0.7057777047*h2_29 + 0.0014185496*h2_30 + 0.1292866468*h2_31) / sqrt(1 + pow(0.2899270356 + -0.0638937205*h2_0 + -0.4068942666*h2_1 + 0.1672300845*h2_2 + 0.1256325990*h2_3 + -0.2099651843*h2_4 + 0.3948958218*h2_5 + -0.1849565357*h2_6 + 0.1376580745*h2_7 + -0.4319192469*h2_8 + -0.1920379996*h2_9 + -0.0246361662*h2_10 + 1.2337454557*h2_11 + -0.4566627741*h2_12 + 0.3912526369*h2_13 + 0.0972468555*h2_14 + -0.2816746235*h2_15 + -0.0321937576*h2_16 + 0.0020162477*h2_17 + -0.3856804371*h2_18 + -0.0190239120*h2_19 + 0.1675126404*h2_20 + 0.4877643585*h2_21 + -0.2383364439*h2_22 + -0.0834619105*h2_23 + -0.3586616516*h2_24 + 0.8997672796*h2_25 + -1.6043225527*h2_26 + 0.4792380929*h2_27 + -0.4394580722*h2_28 + 0.7057777047*h2_29 + 0.0014185496*h2_30 + 0.1292866468*h2_31, 2));
        h3_10 = (0.1718816906 + -0.0797904432*h2_0 + 0.2565281093*h2_1 + 0.5362411737*h2_2 + -0.0329480544*h2_3 + 0.0436188467*h2_4 + 0.0630201176*h2_5 + 0.0266692042*h2_6 + 0.1606783271*h2_7 + -0.1228488684*h2_8 + 0.1035281047*h2_9 + 0.2202232033*h2_10 + 0.0441047922*h2_11 + 0.2402100414*h2_12 + 0.1120640486*h2_13 + 0.1360033751*h2_14 + -0.5472677350*h2_15 + 0.5148102641*h2_16 + 0.2475668341*h2_17 + -0.0954580158*h2_18 + -0.0705106035*h2_19 + 0.0296877697*h2_20 + -0.0711060166*h2_21 + 0.0531502403*h2_22 + 0.1120222509*h2_23 + -0.0050525740*h2_24 + 0.4548061788*h2_25 + -0.2856590748*h2_26 + 0.0210276078*h2_27 + -0.0734262690*h2_28 + -0.0198732000*h2_29 + -0.4338988066*h2_30 + 0.1376096457*h2_31) / sqrt(1 + pow(0.1718816906 + -0.0797904432*h2_0 + 0.2565281093*h2_1 + 0.5362411737*h2_2 + -0.0329480544*h2_3 + 0.0436188467*h2_4 + 0.0630201176*h2_5 + 0.0266692042*h2_6 + 0.1606783271*h2_7 + -0.1228488684*h2_8 + 0.1035281047*h2_9 + 0.2202232033*h2_10 + 0.0441047922*h2_11 + 0.2402100414*h2_12 + 0.1120640486*h2_13 + 0.1360033751*h2_14 + -0.5472677350*h2_15 + 0.5148102641*h2_16 + 0.2475668341*h2_17 + -0.0954580158*h2_18 + -0.0705106035*h2_19 + 0.0296877697*h2_20 + -0.0711060166*h2_21 + 0.0531502403*h2_22 + 0.1120222509*h2_23 + -0.0050525740*h2_24 + 0.4548061788*h2_25 + -0.2856590748*h2_26 + 0.0210276078*h2_27 + -0.0734262690*h2_28 + -0.0198732000*h2_29 + -0.4338988066*h2_30 + 0.1376096457*h2_31, 2));
        h3_11 = (0.1995349228 + -0.1749206185*h2_0 + -0.0711309686*h2_1 + 0.2139800340*h2_2 + -0.0644639954*h2_3 + 0.1079428494*h2_4 + 0.1883834898*h2_5 + -0.1865719706*h2_6 + -0.1184446737*h2_7 + -0.0829700455*h2_8 + -0.3976586759*h2_9 + 0.2260675430*h2_10 + -0.7995232344*h2_11 + -0.3128826916*h2_12 + 0.1375351101*h2_13 + 0.3009307384*h2_14 + -0.3495601416*h2_15 + -0.6362478137*h2_16 + 0.2604734302*h2_17 + 0.0431801416*h2_18 + 0.4332245886*h2_19 + -0.1302875429*h2_20 + 0.3045918941*h2_21 + -0.2109415829*h2_22 + 0.1743984520*h2_23 + -0.1912416369*h2_24 + -0.1331647635*h2_25 + 0.2214611322*h2_26 + -0.0924330279*h2_27 + 0.2568168342*h2_28 + -0.2161896378*h2_29 + -0.0247827396*h2_30 + 0.2392672896*h2_31) / sqrt(1 + pow(0.1995349228 + -0.1749206185*h2_0 + -0.0711309686*h2_1 + 0.2139800340*h2_2 + -0.0644639954*h2_3 + 0.1079428494*h2_4 + 0.1883834898*h2_5 + -0.1865719706*h2_6 + -0.1184446737*h2_7 + -0.0829700455*h2_8 + -0.3976586759*h2_9 + 0.2260675430*h2_10 + -0.7995232344*h2_11 + -0.3128826916*h2_12 + 0.1375351101*h2_13 + 0.3009307384*h2_14 + -0.3495601416*h2_15 + -0.6362478137*h2_16 + 0.2604734302*h2_17 + 0.0431801416*h2_18 + 0.4332245886*h2_19 + -0.1302875429*h2_20 + 0.3045918941*h2_21 + -0.2109415829*h2_22 + 0.1743984520*h2_23 + -0.1912416369*h2_24 + -0.1331647635*h2_25 + 0.2214611322*h2_26 + -0.0924330279*h2_27 + 0.2568168342*h2_28 + -0.2161896378*h2_29 + -0.0247827396*h2_30 + 0.2392672896*h2_31, 2));
        h3_12 = (0.3217357695 + -0.0074858810*h2_0 + -0.1593250483*h2_1 + -0.1470442861*h2_2 + -0.1118108481*h2_3 + -0.1305760890*h2_4 + 0.3828713596*h2_5 + -0.3865813911*h2_6 + 0.3504271507*h2_7 + -0.2334017456*h2_8 + -0.3765151799*h2_9 + 0.0981091782*h2_10 + 0.7147250175*h2_11 + -0.4481665790*h2_12 + 0.3601151407*h2_13 + 0.1473537683*h2_14 + -0.1079586223*h2_15 + -0.1342944205*h2_16 + 0.0364649557*h2_17 + -0.2282156050*h2_18 + 0.4241381586*h2_19 + -0.3237684369*h2_20 + 0.2398864031*h2_21 + 0.0402487107*h2_22 + -0.0122672729*h2_23 + -0.3471746445*h2_24 + 0.4394298792*h2_25 + -0.9452396035*h2_26 + 0.4787402153*h2_27 + -0.4780235589*h2_28 + 0.3232935667*h2_29 + -0.2936133444*h2_30 + 0.3490299284*h2_31) / sqrt(1 + pow(0.3217357695 + -0.0074858810*h2_0 + -0.1593250483*h2_1 + -0.1470442861*h2_2 + -0.1118108481*h2_3 + -0.1305760890*h2_4 + 0.3828713596*h2_5 + -0.3865813911*h2_6 + 0.3504271507*h2_7 + -0.2334017456*h2_8 + -0.3765151799*h2_9 + 0.0981091782*h2_10 + 0.7147250175*h2_11 + -0.4481665790*h2_12 + 0.3601151407*h2_13 + 0.1473537683*h2_14 + -0.1079586223*h2_15 + -0.1342944205*h2_16 + 0.0364649557*h2_17 + -0.2282156050*h2_18 + 0.4241381586*h2_19 + -0.3237684369*h2_20 + 0.2398864031*h2_21 + 0.0402487107*h2_22 + -0.0122672729*h2_23 + -0.3471746445*h2_24 + 0.4394298792*h2_25 + -0.9452396035*h2_26 + 0.4787402153*h2_27 + -0.4780235589*h2_28 + 0.3232935667*h2_29 + -0.2936133444*h2_30 + 0.3490299284*h2_31, 2));
        h3_13 = (0.1222715676 + -0.0487670749*h2_0 + 0.2500810921*h2_1 + 0.8841564059*h2_2 + -0.2500882745*h2_3 + -0.0523618534*h2_4 + -0.2206405699*h2_5 + 0.2159988284*h2_6 + 0.1035728455*h2_7 + 0.0907619596*h2_8 + -0.2328676581*h2_9 + 0.2979883552*h2_10 + -0.4575826526*h2_11 + 0.0490514114*h2_12 + -0.1309250295*h2_13 + 0.5200358033*h2_14 + -0.5935196280*h2_15 + 0.1735344380*h2_16 + -0.1977237910*h2_17 + 0.3833163977*h2_18 + 0.2639112175*h2_19 + -0.0870622173*h2_20 + 0.1204849035*h2_21 + 0.1408687234*h2_22 + 0.3784239888*h2_23 + 0.0485450625*h2_24 + 0.1991198063*h2_25 + -0.5594872832*h2_26 + -0.2458660901*h2_27 + 0.6341642737*h2_28 + -0.3244241178*h2_29 + -0.2024029344*h2_30 + -0.1977570057*h2_31) / sqrt(1 + pow(0.1222715676 + -0.0487670749*h2_0 + 0.2500810921*h2_1 + 0.8841564059*h2_2 + -0.2500882745*h2_3 + -0.0523618534*h2_4 + -0.2206405699*h2_5 + 0.2159988284*h2_6 + 0.1035728455*h2_7 + 0.0907619596*h2_8 + -0.2328676581*h2_9 + 0.2979883552*h2_10 + -0.4575826526*h2_11 + 0.0490514114*h2_12 + -0.1309250295*h2_13 + 0.5200358033*h2_14 + -0.5935196280*h2_15 + 0.1735344380*h2_16 + -0.1977237910*h2_17 + 0.3833163977*h2_18 + 0.2639112175*h2_19 + -0.0870622173*h2_20 + 0.1204849035*h2_21 + 0.1408687234*h2_22 + 0.3784239888*h2_23 + 0.0485450625*h2_24 + 0.1991198063*h2_25 + -0.5594872832*h2_26 + -0.2458660901*h2_27 + 0.6341642737*h2_28 + -0.3244241178*h2_29 + -0.2024029344*h2_30 + -0.1977570057*h2_31, 2));
        h3_14 = (-0.2075958103 + 0.0599071085*h2_0 + 0.4714156687*h2_1 + -0.1259146482*h2_2 + -0.1243480593*h2_3 + 0.2606760561*h2_4 + -0.4008817673*h2_5 + 0.2627796233*h2_6 + -0.2119869292*h2_7 + 0.1676143855*h2_8 + 0.3449281752*h2_9 + 0.2558114529*h2_10 + -1.0803101063*h2_11 + 0.3544973433*h2_12 + -0.4452276826*h2_13 + 0.1281222999*h2_14 + 0.1600458920*h2_15 + -0.2354561388*h2_16 + -0.0004163835*h2_17 + 0.2196848691*h2_18 + -0.0959332958*h2_19 + 0.0078830225*h2_20 + -0.2260225266*h2_21 + 0.2781426311*h2_22 + 0.0757441968*h2_23 + 0.1498328596*h2_24 + -0.6097602844*h2_25 + 1.3999116421*h2_26 + -0.6794649363*h2_27 + 0.1805244684*h2_28 + -0.6747810245*h2_29 + -0.0070203687*h2_30 + -0.3850861192*h2_31) / sqrt(1 + pow(-0.2075958103 + 0.0599071085*h2_0 + 0.4714156687*h2_1 + -0.1259146482*h2_2 + -0.1243480593*h2_3 + 0.2606760561*h2_4 + -0.4008817673*h2_5 + 0.2627796233*h2_6 + -0.2119869292*h2_7 + 0.1676143855*h2_8 + 0.3449281752*h2_9 + 0.2558114529*h2_10 + -1.0803101063*h2_11 + 0.3544973433*h2_12 + -0.4452276826*h2_13 + 0.1281222999*h2_14 + 0.1600458920*h2_15 + -0.2354561388*h2_16 + -0.0004163835*h2_17 + 0.2196848691*h2_18 + -0.0959332958*h2_19 + 0.0078830225*h2_20 + -0.2260225266*h2_21 + 0.2781426311*h2_22 + 0.0757441968*h2_23 + 0.1498328596*h2_24 + -0.6097602844*h2_25 + 1.3999116421*h2_26 + -0.6794649363*h2_27 + 0.1805244684*h2_28 + -0.6747810245*h2_29 + -0.0070203687*h2_30 + -0.3850861192*h2_31, 2));
        h3_15 = (0.3076358438 + 0.1367722750*h2_0 + -0.4304558933*h2_1 + -0.0061535304*h2_2 + 0.0648061410*h2_3 + 0.0014538843*h2_4 + 0.3026751578*h2_5 + -0.3881442547*h2_6 + 0.3824375868*h2_7 + -0.3802472055*h2_8 + -0.2172159702*h2_9 + 0.2102461457*h2_10 + 0.6630594134*h2_11 + -0.3103692830*h2_12 + 0.0972121358*h2_13 + 0.1105885580*h2_14 + -0.0140789952*h2_15 + -0.2463090271*h2_16 + 0.0928727090*h2_17 + -0.2126096487*h2_18 + 0.2656081915*h2_19 + -0.0573240444*h2_20 + 0.3038164973*h2_21 + -0.2055032253*h2_22 + -0.2951764166*h2_23 + -0.2708326280*h2_24 + 0.1788961589*h2_25 + -0.9145278931*h2_26 + 0.3775804341*h2_27 + -0.3124755919*h2_28 + 0.3555765450*h2_29 + -0.2928262651*h2_30 + 0.0056582387*h2_31) / sqrt(1 + pow(0.3076358438 + 0.1367722750*h2_0 + -0.4304558933*h2_1 + -0.0061535304*h2_2 + 0.0648061410*h2_3 + 0.0014538843*h2_4 + 0.3026751578*h2_5 + -0.3881442547*h2_6 + 0.3824375868*h2_7 + -0.3802472055*h2_8 + -0.2172159702*h2_9 + 0.2102461457*h2_10 + 0.6630594134*h2_11 + -0.3103692830*h2_12 + 0.0972121358*h2_13 + 0.1105885580*h2_14 + -0.0140789952*h2_15 + -0.2463090271*h2_16 + 0.0928727090*h2_17 + -0.2126096487*h2_18 + 0.2656081915*h2_19 + -0.0573240444*h2_20 + 0.3038164973*h2_21 + -0.2055032253*h2_22 + -0.2951764166*h2_23 + -0.2708326280*h2_24 + 0.1788961589*h2_25 + -0.9145278931*h2_26 + 0.3775804341*h2_27 + -0.3124755919*h2_28 + 0.3555765450*h2_29 + -0.2928262651*h2_30 + 0.0056582387*h2_31, 2));
        h3_16 = (0.2263220847 + -0.0969756767*h2_0 + -0.1786204875*h2_1 + -0.1207183599*h2_2 + -0.0153971808*h2_3 + 0.0770450756*h2_4 + 0.1341695786*h2_5 + 0.1423205882*h2_6 + 0.0011931147*h2_7 + -0.0864734277*h2_8 + -0.0575789772*h2_9 + -0.1699394882*h2_10 + -0.4963022768*h2_11 + -0.3740727305*h2_12 + -0.1962975264*h2_13 + 0.0716441944*h2_14 + -0.2530890405*h2_15 + -0.4213775992*h2_16 + 0.2348735482*h2_17 + -0.0782107860*h2_18 + 0.3841093183*h2_19 + -0.3877022266*h2_20 + -0.0535235703*h2_21 + -0.0719890520*h2_22 + 0.1036719978*h2_23 + -0.1655668914*h2_24 + -0.0527340360*h2_25 + 0.0628916845*h2_26 + -0.2599656880*h2_27 + 0.4993311465*h2_28 + -0.0939937159*h2_29 + 0.2178333998*h2_30 + -0.0016722672*h2_31) / sqrt(1 + pow(0.2263220847 + -0.0969756767*h2_0 + -0.1786204875*h2_1 + -0.1207183599*h2_2 + -0.0153971808*h2_3 + 0.0770450756*h2_4 + 0.1341695786*h2_5 + 0.1423205882*h2_6 + 0.0011931147*h2_7 + -0.0864734277*h2_8 + -0.0575789772*h2_9 + -0.1699394882*h2_10 + -0.4963022768*h2_11 + -0.3740727305*h2_12 + -0.1962975264*h2_13 + 0.0716441944*h2_14 + -0.2530890405*h2_15 + -0.4213775992*h2_16 + 0.2348735482*h2_17 + -0.0782107860*h2_18 + 0.3841093183*h2_19 + -0.3877022266*h2_20 + -0.0535235703*h2_21 + -0.0719890520*h2_22 + 0.1036719978*h2_23 + -0.1655668914*h2_24 + -0.0527340360*h2_25 + 0.0628916845*h2_26 + -0.2599656880*h2_27 + 0.4993311465*h2_28 + -0.0939937159*h2_29 + 0.2178333998*h2_30 + -0.0016722672*h2_31, 2));
        h3_17 = (0.3992693722 + -0.0654845834*h2_0 + -0.0946908817*h2_1 + -0.0510065109*h2_2 + -0.2053181827*h2_3 + -0.0499020144*h2_4 + 0.4021295905*h2_5 + -0.4190993011*h2_6 + 0.4132806957*h2_7 + -0.1659434438*h2_8 + -0.2967281342*h2_9 + 0.1657740027*h2_10 + 0.1022766083*h2_11 + -0.3931809664*h2_12 + 0.4161561430*h2_13 + -0.0130076017*h2_14 + -0.2006351799*h2_15 + -0.4907623231*h2_16 + 0.4232483804*h2_17 + -0.0654406473*h2_18 + 0.2627059519*h2_19 + -0.2906298041*h2_20 + 0.1963782161*h2_21 + -0.3244464099*h2_22 + -0.1257578433*h2_23 + -0.4379206002*h2_24 + 0.1037911475*h2_25 + -0.5865920782*h2_26 + 0.1843904853*h2_27 + 0.0080034249*h2_28 + 0.3789108992*h2_29 + 0.0739349499*h2_30 + 0.0313529968*h2_31) / sqrt(1 + pow(0.3992693722 + -0.0654845834*h2_0 + -0.0946908817*h2_1 + -0.0510065109*h2_2 + -0.2053181827*h2_3 + -0.0499020144*h2_4 + 0.4021295905*h2_5 + -0.4190993011*h2_6 + 0.4132806957*h2_7 + -0.1659434438*h2_8 + -0.2967281342*h2_9 + 0.1657740027*h2_10 + 0.1022766083*h2_11 + -0.3931809664*h2_12 + 0.4161561430*h2_13 + -0.0130076017*h2_14 + -0.2006351799*h2_15 + -0.4907623231*h2_16 + 0.4232483804*h2_17 + -0.0654406473*h2_18 + 0.2627059519*h2_19 + -0.2906298041*h2_20 + 0.1963782161*h2_21 + -0.3244464099*h2_22 + -0.1257578433*h2_23 + -0.4379206002*h2_24 + 0.1037911475*h2_25 + -0.5865920782*h2_26 + 0.1843904853*h2_27 + 0.0080034249*h2_28 + 0.3789108992*h2_29 + 0.0739349499*h2_30 + 0.0313529968*h2_31, 2));
        h3_18 = (-0.3782742918 + 0.0635756999*h2_0 + 0.2197201997*h2_1 + 0.0596529804*h2_2 + -0.0205879491*h2_3 + 0.1990394741*h2_4 + -0.3704585135*h2_5 + 0.2889762521*h2_6 + -0.0614304170*h2_7 + 0.2592629194*h2_8 + 0.4192934632*h2_9 + 0.1159807071*h2_10 + 0.1303500086*h2_11 + 0.3558759987*h2_12 + -0.0822273567*h2_13 + -0.0001521794*h2_14 + 0.0372880735*h2_15 + 0.4836514294*h2_16 + -0.1704013497*h2_17 + -0.0272604749*h2_18 + -0.3534556329*h2_19 + 0.1743688583*h2_20 + -0.3022609055*h2_21 + 0.3283963203*h2_22 + 0.2960600853*h2_23 + 0.2502674460*h2_24 + -0.1186219081*h2_25 + 0.4444053471*h2_26 + -0.0947100669*h2_27 + 0.0198517852*h2_28 + -0.3249494731*h2_29 + -0.0640477538*h2_30 + 0.0895901322*h2_31) / sqrt(1 + pow(-0.3782742918 + 0.0635756999*h2_0 + 0.2197201997*h2_1 + 0.0596529804*h2_2 + -0.0205879491*h2_3 + 0.1990394741*h2_4 + -0.3704585135*h2_5 + 0.2889762521*h2_6 + -0.0614304170*h2_7 + 0.2592629194*h2_8 + 0.4192934632*h2_9 + 0.1159807071*h2_10 + 0.1303500086*h2_11 + 0.3558759987*h2_12 + -0.0822273567*h2_13 + -0.0001521794*h2_14 + 0.0372880735*h2_15 + 0.4836514294*h2_16 + -0.1704013497*h2_17 + -0.0272604749*h2_18 + -0.3534556329*h2_19 + 0.1743688583*h2_20 + -0.3022609055*h2_21 + 0.3283963203*h2_22 + 0.2960600853*h2_23 + 0.2502674460*h2_24 + -0.1186219081*h2_25 + 0.4444053471*h2_26 + -0.0947100669*h2_27 + 0.0198517852*h2_28 + -0.3249494731*h2_29 + -0.0640477538*h2_30 + 0.0895901322*h2_31, 2));
        h3_19 = (0.2874320149 + 0.0555945076*h2_0 + -0.1901788116*h2_1 + -0.0131236557*h2_2 + -0.2056401372*h2_3 + -0.0925479233*h2_4 + 0.1849583685*h2_5 + 0.0640737116*h2_6 + 0.1118072569*h2_7 + -0.2767054439*h2_8 + -0.2678378522*h2_9 + 0.1458949447*h2_10 + -0.7763921618*h2_11 + -0.2913002670*h2_12 + 0.1420676708*h2_13 + 0.1390322298*h2_14 + -0.1494046301*h2_15 + -0.4923080504*h2_16 + 0.2838069797*h2_17 + -0.1866233051*h2_18 + 0.2684813738*h2_19 + -0.1537722051*h2_20 + -0.0966994092*h2_21 + -0.0044829231*h2_22 + -0.0824686512*h2_23 + 0.0278016515*h2_24 + 0.0322001278*h2_25 + -0.2870415449*h2_26 + -0.2029885352*h2_27 + 0.3075732291*h2_28 + -0.1803947687*h2_29 + 0.1153649092*h2_30 + 0.1500383019*h2_31) / sqrt(1 + pow(0.2874320149 + 0.0555945076*h2_0 + -0.1901788116*h2_1 + -0.0131236557*h2_2 + -0.2056401372*h2_3 + -0.0925479233*h2_4 + 0.1849583685*h2_5 + 0.0640737116*h2_6 + 0.1118072569*h2_7 + -0.2767054439*h2_8 + -0.2678378522*h2_9 + 0.1458949447*h2_10 + -0.7763921618*h2_11 + -0.2913002670*h2_12 + 0.1420676708*h2_13 + 0.1390322298*h2_14 + -0.1494046301*h2_15 + -0.4923080504*h2_16 + 0.2838069797*h2_17 + -0.1866233051*h2_18 + 0.2684813738*h2_19 + -0.1537722051*h2_20 + -0.0966994092*h2_21 + -0.0044829231*h2_22 + -0.0824686512*h2_23 + 0.0278016515*h2_24 + 0.0322001278*h2_25 + -0.2870415449*h2_26 + -0.2029885352*h2_27 + 0.3075732291*h2_28 + -0.1803947687*h2_29 + 0.1153649092*h2_30 + 0.1500383019*h2_31, 2));
        h3_20 = (0.2152737528 + -0.3675157130*h2_0 + -0.0942738280*h2_1 + 1.0096889734*h2_2 + -0.3003783226*h2_3 + -0.0473830700*h2_4 + 0.3311646283*h2_5 + -0.0954698995*h2_6 + 0.1792872995*h2_7 + 0.1571165770*h2_8 + -0.1924846470*h2_9 + 0.3280644715*h2_10 + 0.3405929208*h2_11 + 0.0912069231*h2_12 + -0.0024870734*h2_13 + 0.5883150101*h2_14 + -0.4174644649*h2_15 + -0.1241791844*h2_16 + 0.2787648737*h2_17 + 0.2741614282*h2_18 + 0.0632487237*h2_19 + -0.1336424202*h2_20 + -0.1699333787*h2_21 + 0.0983573794*h2_22 + -0.0777780265*h2_23 + -0.2753821909*h2_24 + 0.2880370617*h2_25 + 0.2155490518*h2_26 + 0.1194559932*h2_27 + 0.3140932918*h2_28 + -0.0423048995*h2_29 + -0.1647172421*h2_30 + 0.2231492102*h2_31) / sqrt(1 + pow(0.2152737528 + -0.3675157130*h2_0 + -0.0942738280*h2_1 + 1.0096889734*h2_2 + -0.3003783226*h2_3 + -0.0473830700*h2_4 + 0.3311646283*h2_5 + -0.0954698995*h2_6 + 0.1792872995*h2_7 + 0.1571165770*h2_8 + -0.1924846470*h2_9 + 0.3280644715*h2_10 + 0.3405929208*h2_11 + 0.0912069231*h2_12 + -0.0024870734*h2_13 + 0.5883150101*h2_14 + -0.4174644649*h2_15 + -0.1241791844*h2_16 + 0.2787648737*h2_17 + 0.2741614282*h2_18 + 0.0632487237*h2_19 + -0.1336424202*h2_20 + -0.1699333787*h2_21 + 0.0983573794*h2_22 + -0.0777780265*h2_23 + -0.2753821909*h2_24 + 0.2880370617*h2_25 + 0.2155490518*h2_26 + 0.1194559932*h2_27 + 0.3140932918*h2_28 + -0.0423048995*h2_29 + -0.1647172421*h2_30 + 0.2231492102*h2_31, 2));
        h3_21 = (-0.2662607431 + -0.2689687908*h2_0 + 0.4151816666*h2_1 + -0.2295779288*h2_2 + -0.1430186778*h2_3 + 0.2668850720*h2_4 + -0.2900995314*h2_5 + 0.6371610761*h2_6 + -0.3171406686*h2_7 + 0.4602357447*h2_8 + 0.3467566967*h2_9 + 0.0119198915*h2_10 + -1.4709129333*h2_11 + 0.0798138902*h2_12 + -0.5862153769*h2_13 + 0.2334127426*h2_14 + 0.3301116824*h2_15 + -0.3526121974*h2_16 + 0.0484087579*h2_17 + 0.1140551344*h2_18 + 0.1155563593*h2_19 + -0.3363088071*h2_20 + -0.6359937787*h2_21 + 0.0382000767*h2_22 + -0.0412835330*h2_23 + 0.1348274201*h2_24 + -0.8942075968*h2_25 + 1.5497095585*h2_26 + -0.8702430725*h2_27 + 0.4664346576*h2_28 + -0.8336735368*h2_29 + 0.2213701308*h2_30 + -0.5088940263*h2_31) / sqrt(1 + pow(-0.2662607431 + -0.2689687908*h2_0 + 0.4151816666*h2_1 + -0.2295779288*h2_2 + -0.1430186778*h2_3 + 0.2668850720*h2_4 + -0.2900995314*h2_5 + 0.6371610761*h2_6 + -0.3171406686*h2_7 + 0.4602357447*h2_8 + 0.3467566967*h2_9 + 0.0119198915*h2_10 + -1.4709129333*h2_11 + 0.0798138902*h2_12 + -0.5862153769*h2_13 + 0.2334127426*h2_14 + 0.3301116824*h2_15 + -0.3526121974*h2_16 + 0.0484087579*h2_17 + 0.1140551344*h2_18 + 0.1155563593*h2_19 + -0.3363088071*h2_20 + -0.6359937787*h2_21 + 0.0382000767*h2_22 + -0.0412835330*h2_23 + 0.1348274201*h2_24 + -0.8942075968*h2_25 + 1.5497095585*h2_26 + -0.8702430725*h2_27 + 0.4664346576*h2_28 + -0.8336735368*h2_29 + 0.2213701308*h2_30 + -0.5088940263*h2_31, 2));
        h3_22 = (-0.1426031590 + 0.3112978935*h2_0 + 1.2184731960*h2_1 + 0.2803130150*h2_2 + 0.1494850516*h2_3 + 0.1791898757*h2_4 + -0.2153527439*h2_5 + 0.0865408778*h2_6 + -0.0517914556*h2_7 + -0.3222897947*h2_8 + -0.0350669883*h2_9 + -0.2521278858*h2_10 + -0.9195287824*h2_11 + -0.0689117610*h2_12 + -0.1071363837*h2_13 + 0.2228941023*h2_14 + -0.0145269800*h2_15 + 0.1349885017*h2_16 + -0.1605829746*h2_17 + 0.3963896632*h2_18 + -0.0301701389*h2_19 + 0.3636071086*h2_20 + 0.2369070947*h2_21 + -0.1465661526*h2_22 + 0.3104480505*h2_23 + 0.0321949944*h2_24 + -1.2120114565*h2_25 + 0.0853082538*h2_26 + -0.0762116164*h2_27 + 0.2157325894*h2_28 + -0.3255123794*h2_29 + 0.1714997739*h2_30 + -0.0237454213*h2_31) / sqrt(1 + pow(-0.1426031590 + 0.3112978935*h2_0 + 1.2184731960*h2_1 + 0.2803130150*h2_2 + 0.1494850516*h2_3 + 0.1791898757*h2_4 + -0.2153527439*h2_5 + 0.0865408778*h2_6 + -0.0517914556*h2_7 + -0.3222897947*h2_8 + -0.0350669883*h2_9 + -0.2521278858*h2_10 + -0.9195287824*h2_11 + -0.0689117610*h2_12 + -0.1071363837*h2_13 + 0.2228941023*h2_14 + -0.0145269800*h2_15 + 0.1349885017*h2_16 + -0.1605829746*h2_17 + 0.3963896632*h2_18 + -0.0301701389*h2_19 + 0.3636071086*h2_20 + 0.2369070947*h2_21 + -0.1465661526*h2_22 + 0.3104480505*h2_23 + 0.0321949944*h2_24 + -1.2120114565*h2_25 + 0.0853082538*h2_26 + -0.0762116164*h2_27 + 0.2157325894*h2_28 + -0.3255123794*h2_29 + 0.1714997739*h2_30 + -0.0237454213*h2_31, 2));
        h3_23 = (0.2770986259 + -0.0739154518*h2_0 + -0.3604811728*h2_1 + -0.0181247760*h2_2 + 0.0947904214*h2_3 + 0.0253431480*h2_4 + 0.0513481908*h2_5 + -0.3365136087*h2_6 + 0.0020332888*h2_7 + -0.1961163282*h2_8 + -0.2236481309*h2_9 + -0.1992408186*h2_10 + 0.5797985196*h2_11 + -0.4063145816*h2_12 + 0.4247528613*h2_13 + 0.0047304896*h2_14 + -0.1534049660*h2_15 + -0.2128639966*h2_16 + 0.1750201583*h2_17 + -0.0258486439*h2_18 + 0.0151258260*h2_19 + -0.1059608683*h2_20 + 0.3543246984*h2_21 + -0.1631619930*h2_22 + -0.2286200374*h2_23 + -0.2440435439*h2_24 + 0.3543530107*h2_25 + -0.9896119833*h2_26 + 0.1911722273*h2_27 + -0.2833543122*h2_28 + 0.3860108256*h2_29 + 0.0742978901*h2_30 + 0.3464562893*h2_31) / sqrt(1 + pow(0.2770986259 + -0.0739154518*h2_0 + -0.3604811728*h2_1 + -0.0181247760*h2_2 + 0.0947904214*h2_3 + 0.0253431480*h2_4 + 0.0513481908*h2_5 + -0.3365136087*h2_6 + 0.0020332888*h2_7 + -0.1961163282*h2_8 + -0.2236481309*h2_9 + -0.1992408186*h2_10 + 0.5797985196*h2_11 + -0.4063145816*h2_12 + 0.4247528613*h2_13 + 0.0047304896*h2_14 + -0.1534049660*h2_15 + -0.2128639966*h2_16 + 0.1750201583*h2_17 + -0.0258486439*h2_18 + 0.0151258260*h2_19 + -0.1059608683*h2_20 + 0.3543246984*h2_21 + -0.1631619930*h2_22 + -0.2286200374*h2_23 + -0.2440435439*h2_24 + 0.3543530107*h2_25 + -0.9896119833*h2_26 + 0.1911722273*h2_27 + -0.2833543122*h2_28 + 0.3860108256*h2_29 + 0.0742978901*h2_30 + 0.3464562893*h2_31, 2));
        h3_24 = (-0.0793003887 + 0.0730301291*h2_0 + 0.3652088046*h2_1 + -0.4688006639*h2_2 + 0.1782758087*h2_3 + 0.0688502342*h2_4 + 0.2032950372*h2_5 + -0.1383859962*h2_6 + 0.2959265411*h2_7 + -0.4352121353*h2_8 + -0.0315749571*h2_9 + -0.1073242947*h2_10 + 0.1635518372*h2_11 + -0.2041054815*h2_12 + -0.0662911907*h2_13 + 0.0561585240*h2_14 + 0.1433047056*h2_15 + 0.2283178419*h2_16 + -0.0741783381*h2_17 + 0.3074144721*h2_18 + 0.0082665067*h2_19 + 0.1688305140*h2_20 + 0.2887519002*h2_21 + -0.3481717408*h2_22 + -0.2780910432*h2_23 + -0.0368498899*h2_24 + -0.1960649639*h2_25 + -0.1283944249*h2_26 + 0.1476223320*h2_27 + -0.5646945238*h2_28 + 0.6426310539*h2_29 + 0.3843255043*h2_30 + 0.1874047220*h2_31) / sqrt(1 + pow(-0.0793003887 + 0.0730301291*h2_0 + 0.3652088046*h2_1 + -0.4688006639*h2_2 + 0.1782758087*h2_3 + 0.0688502342*h2_4 + 0.2032950372*h2_5 + -0.1383859962*h2_6 + 0.2959265411*h2_7 + -0.4352121353*h2_8 + -0.0315749571*h2_9 + -0.1073242947*h2_10 + 0.1635518372*h2_11 + -0.2041054815*h2_12 + -0.0662911907*h2_13 + 0.0561585240*h2_14 + 0.1433047056*h2_15 + 0.2283178419*h2_16 + -0.0741783381*h2_17 + 0.3074144721*h2_18 + 0.0082665067*h2_19 + 0.1688305140*h2_20 + 0.2887519002*h2_21 + -0.3481717408*h2_22 + -0.2780910432*h2_23 + -0.0368498899*h2_24 + -0.1960649639*h2_25 + -0.1283944249*h2_26 + 0.1476223320*h2_27 + -0.5646945238*h2_28 + 0.6426310539*h2_29 + 0.3843255043*h2_30 + 0.1874047220*h2_31, 2));
        h3_25 = (0.1622355431 + -0.0660057366*h2_0 + -0.0062399348*h2_1 + 0.9131439924*h2_2 + -0.1962676644*h2_3 + 0.0449580997*h2_4 + -0.0127474023*h2_5 + -0.1801146716*h2_6 + -0.0850476250*h2_7 + 0.1069043875*h2_8 + -0.1139309928*h2_9 + 0.0197828673*h2_10 + -0.0714590028*h2_11 + 0.0551022552*h2_12 + -0.1064374968*h2_13 + 0.3807836175*h2_14 + -0.4239725173*h2_15 + 0.3170091808*h2_16 + -0.1303986460*h2_17 + -0.0196688008*h2_18 + 0.0947450623*h2_19 + 0.1872646809*h2_20 + 0.2413831204*h2_21 + 0.0890551507*h2_22 + 0.2200761139*h2_23 + -0.1029322967*h2_24 + 0.3906421959*h2_25 + 0.0568575375*h2_26 + -0.2466654480*h2_27 + 0.0915548205*h2_28 + -0.0747137070*h2_29 + -0.2677611113*h2_30 + -0.0703915209*h2_31) / sqrt(1 + pow(0.1622355431 + -0.0660057366*h2_0 + -0.0062399348*h2_1 + 0.9131439924*h2_2 + -0.1962676644*h2_3 + 0.0449580997*h2_4 + -0.0127474023*h2_5 + -0.1801146716*h2_6 + -0.0850476250*h2_7 + 0.1069043875*h2_8 + -0.1139309928*h2_9 + 0.0197828673*h2_10 + -0.0714590028*h2_11 + 0.0551022552*h2_12 + -0.1064374968*h2_13 + 0.3807836175*h2_14 + -0.4239725173*h2_15 + 0.3170091808*h2_16 + -0.1303986460*h2_17 + -0.0196688008*h2_18 + 0.0947450623*h2_19 + 0.1872646809*h2_20 + 0.2413831204*h2_21 + 0.0890551507*h2_22 + 0.2200761139*h2_23 + -0.1029322967*h2_24 + 0.3906421959*h2_25 + 0.0568575375*h2_26 + -0.2466654480*h2_27 + 0.0915548205*h2_28 + -0.0747137070*h2_29 + -0.2677611113*h2_30 + -0.0703915209*h2_31, 2));
        h3_26 = (0.2827256918 + -0.1072161794*h2_0 + -0.3281336129*h2_1 + 0.0047742715*h2_2 + 0.1572597176*h2_3 + -0.3715438843*h2_4 + 0.3311544061*h2_5 + -0.4228163362*h2_6 + 0.2373607308*h2_7 + -0.2730109096*h2_8 + -0.2165588140*h2_9 + -0.0006321064*h2_10 + 1.0457332134*h2_11 + -0.3316718638*h2_12 + 0.4492911100*h2_13 + -0.2883814573*h2_14 + -0.0249979459*h2_15 + 0.0017450691*h2_16 + -0.0655129179*h2_17 + -0.0951105505*h2_18 + 0.1342076957*h2_19 + -0.1710457206*h2_20 + 0.3908852041*h2_21 + -0.1999999285*h2_22 + 0.1567042768*h2_23 + -0.2178235352*h2_24 + 0.7825428843*h2_25 + -1.2926374674*h2_26 + 0.4805714190*h2_27 + -0.1267542839*h2_28 + 0.5247514248*h2_29 + -0.1779819280*h2_30 + 0.2659713328*h2_31) / sqrt(1 + pow(0.2827256918 + -0.1072161794*h2_0 + -0.3281336129*h2_1 + 0.0047742715*h2_2 + 0.1572597176*h2_3 + -0.3715438843*h2_4 + 0.3311544061*h2_5 + -0.4228163362*h2_6 + 0.2373607308*h2_7 + -0.2730109096*h2_8 + -0.2165588140*h2_9 + -0.0006321064*h2_10 + 1.0457332134*h2_11 + -0.3316718638*h2_12 + 0.4492911100*h2_13 + -0.2883814573*h2_14 + -0.0249979459*h2_15 + 0.0017450691*h2_16 + -0.0655129179*h2_17 + -0.0951105505*h2_18 + 0.1342076957*h2_19 + -0.1710457206*h2_20 + 0.3908852041*h2_21 + -0.1999999285*h2_22 + 0.1567042768*h2_23 + -0.2178235352*h2_24 + 0.7825428843*h2_25 + -1.2926374674*h2_26 + 0.4805714190*h2_27 + -0.1267542839*h2_28 + 0.5247514248*h2_29 + -0.1779819280*h2_30 + 0.2659713328*h2_31, 2));
        h3_27 = (-0.1150206923 + 0.2199902833*h2_0 + 1.3623110056*h2_1 + -0.1316986084*h2_2 + 0.3694109023*h2_3 + -0.2936400473*h2_4 + -0.0659019426*h2_5 + 0.1478815824*h2_6 + 0.0052237324*h2_7 + -0.7727679014*h2_8 + -0.2541091442*h2_9 + -0.0406264812*h2_10 + -0.8664413095*h2_11 + 0.0146663617*h2_12 + 0.1697407663*h2_13 + 0.0552619956*h2_14 + 0.0836045146*h2_15 + -0.0002937502*h2_16 + -0.1063413769*h2_17 + -0.0797400102*h2_18 + 0.1880258322*h2_19 + 0.0045239641*h2_20 + 1.0387983322*h2_21 + -0.0118830958*h2_22 + 0.1021083295*h2_23 + -0.3773880601*h2_24 + -1.2003110647*h2_25 + -0.5979219675*h2_26 + 0.2744504213*h2_27 + 0.0820265859*h2_28 + -0.1051897109*h2_29 + 0.3339978755*h2_30 + 0.1830975562*h2_31) / sqrt(1 + pow(-0.1150206923 + 0.2199902833*h2_0 + 1.3623110056*h2_1 + -0.1316986084*h2_2 + 0.3694109023*h2_3 + -0.2936400473*h2_4 + -0.0659019426*h2_5 + 0.1478815824*h2_6 + 0.0052237324*h2_7 + -0.7727679014*h2_8 + -0.2541091442*h2_9 + -0.0406264812*h2_10 + -0.8664413095*h2_11 + 0.0146663617*h2_12 + 0.1697407663*h2_13 + 0.0552619956*h2_14 + 0.0836045146*h2_15 + -0.0002937502*h2_16 + -0.1063413769*h2_17 + -0.0797400102*h2_18 + 0.1880258322*h2_19 + 0.0045239641*h2_20 + 1.0387983322*h2_21 + -0.0118830958*h2_22 + 0.1021083295*h2_23 + -0.3773880601*h2_24 + -1.2003110647*h2_25 + -0.5979219675*h2_26 + 0.2744504213*h2_27 + 0.0820265859*h2_28 + -0.1051897109*h2_29 + 0.3339978755*h2_30 + 0.1830975562*h2_31, 2));
        h3_28 = (0.2229571491 + 0.2001625597*h2_0 + -0.2255771011*h2_1 + 0.3155885935*h2_2 + 0.1496521980*h2_3 + -0.1144886464*h2_4 + 0.1438744813*h2_5 + -0.3673047423*h2_6 + 0.0695463941*h2_7 + -0.0501723699*h2_8 + -0.3746464252*h2_9 + -0.1965115964*h2_10 + 0.3233437240*h2_11 + -0.1052182913*h2_12 + 0.2074359059*h2_13 + -0.0815473720*h2_14 + -0.3131390214*h2_15 + 0.1487735659*h2_16 + 0.0099567659*h2_17 + -0.2020140439*h2_18 + 0.1913695186*h2_19 + -0.1571679413*h2_20 + 0.2300386727*h2_21 + -0.0081221871*h2_22 + -0.0844502002*h2_23 + 0.0510663502*h2_24 + 0.1147428751*h2_25 + -0.8166506290*h2_26 + 0.1811233461*h2_27 + 0.0876185298*h2_28 + 0.3210619986*h2_29 + -0.2747539282*h2_30 + 0.2313988656*h2_31) / sqrt(1 + pow(0.2229571491 + 0.2001625597*h2_0 + -0.2255771011*h2_1 + 0.3155885935*h2_2 + 0.1496521980*h2_3 + -0.1144886464*h2_4 + 0.1438744813*h2_5 + -0.3673047423*h2_6 + 0.0695463941*h2_7 + -0.0501723699*h2_8 + -0.3746464252*h2_9 + -0.1965115964*h2_10 + 0.3233437240*h2_11 + -0.1052182913*h2_12 + 0.2074359059*h2_13 + -0.0815473720*h2_14 + -0.3131390214*h2_15 + 0.1487735659*h2_16 + 0.0099567659*h2_17 + -0.2020140439*h2_18 + 0.1913695186*h2_19 + -0.1571679413*h2_20 + 0.2300386727*h2_21 + -0.0081221871*h2_22 + -0.0844502002*h2_23 + 0.0510663502*h2_24 + 0.1147428751*h2_25 + -0.8166506290*h2_26 + 0.1811233461*h2_27 + 0.0876185298*h2_28 + 0.3210619986*h2_29 + -0.2747539282*h2_30 + 0.2313988656*h2_31, 2));
        h3_29 = (-0.1180108264 + 0.0741312429*h2_0 + 0.8508373499*h2_1 + 0.4624337256*h2_2 + -0.1417664587*h2_3 + 0.2338903248*h2_4 + 0.0013660906*h2_5 + -0.0774701312*h2_6 + 0.0857926905*h2_7 + 0.2006778121*h2_8 + 0.1205789745*h2_9 + -0.1471111625*h2_10 + -1.2833622694*h2_11 + 0.2154232711*h2_12 + -0.0854528695*h2_13 + 0.0798454359*h2_14 + 0.0687412471*h2_15 + -0.1238347441*h2_16 + -0.1275179684*h2_17 + 0.4008325636*h2_18 + 0.0967597514*h2_19 + 0.3705154955*h2_20 + 0.2495445013*h2_21 + -0.0522782952*h2_22 + 0.2812123597*h2_23 + 0.1588707119*h2_24 + -0.9145770669*h2_25 + 0.1150225103*h2_26 + -0.2519859076*h2_27 + 0.5709164143*h2_28 + -0.6170037389*h2_29 + 0.0789640173*h2_30 + 0.1259229034*h2_31) / sqrt(1 + pow(-0.1180108264 + 0.0741312429*h2_0 + 0.8508373499*h2_1 + 0.4624337256*h2_2 + -0.1417664587*h2_3 + 0.2338903248*h2_4 + 0.0013660906*h2_5 + -0.0774701312*h2_6 + 0.0857926905*h2_7 + 0.2006778121*h2_8 + 0.1205789745*h2_9 + -0.1471111625*h2_10 + -1.2833622694*h2_11 + 0.2154232711*h2_12 + -0.0854528695*h2_13 + 0.0798454359*h2_14 + 0.0687412471*h2_15 + -0.1238347441*h2_16 + -0.1275179684*h2_17 + 0.4008325636*h2_18 + 0.0967597514*h2_19 + 0.3705154955*h2_20 + 0.2495445013*h2_21 + -0.0522782952*h2_22 + 0.2812123597*h2_23 + 0.1588707119*h2_24 + -0.9145770669*h2_25 + 0.1150225103*h2_26 + -0.2519859076*h2_27 + 0.5709164143*h2_28 + -0.6170037389*h2_29 + 0.0789640173*h2_30 + 0.1259229034*h2_31, 2));
        h3_30 = (-0.1617835909 + 0.1610649973*h2_0 + 0.0527564064*h2_1 + -1.3652651310*h2_2 + 0.2130558789*h2_3 + 0.0925558582*h2_4 + -0.1532865316*h2_5 + -0.1423315853*h2_6 + -0.1943877935*h2_7 + -0.1752217710*h2_8 + 0.0656639412*h2_9 + -0.1903665364*h2_10 + 0.1024479270*h2_11 + -0.0521568581*h2_12 + 0.1416675448*h2_13 + -0.3935628533*h2_14 + 0.2359364033*h2_15 + 0.2851275206*h2_16 + -0.2048331648*h2_17 + -0.5249938965*h2_18 + -0.3466241062*h2_19 + 0.1081730351*h2_20 + -0.1195945442*h2_21 + 0.0485549979*h2_22 + 0.0621674471*h2_23 + -0.1333587915*h2_24 + -0.2571743429*h2_25 + -0.3104240000*h2_26 + 0.0956163928*h2_27 + -0.3723907471*h2_28 + 0.1765496135*h2_29 + 0.2462573498*h2_30 + 0.0295623690*h2_31) / sqrt(1 + pow(-0.1617835909 + 0.1610649973*h2_0 + 0.0527564064*h2_1 + -1.3652651310*h2_2 + 0.2130558789*h2_3 + 0.0925558582*h2_4 + -0.1532865316*h2_5 + -0.1423315853*h2_6 + -0.1943877935*h2_7 + -0.1752217710*h2_8 + 0.0656639412*h2_9 + -0.1903665364*h2_10 + 0.1024479270*h2_11 + -0.0521568581*h2_12 + 0.1416675448*h2_13 + -0.3935628533*h2_14 + 0.2359364033*h2_15 + 0.2851275206*h2_16 + -0.2048331648*h2_17 + -0.5249938965*h2_18 + -0.3466241062*h2_19 + 0.1081730351*h2_20 + -0.1195945442*h2_21 + 0.0485549979*h2_22 + 0.0621674471*h2_23 + -0.1333587915*h2_24 + -0.2571743429*h2_25 + -0.3104240000*h2_26 + 0.0956163928*h2_27 + -0.3723907471*h2_28 + 0.1765496135*h2_29 + 0.2462573498*h2_30 + 0.0295623690*h2_31, 2));
        h3_31 = (0.2470845729 + -0.0579673387*h2_0 + -0.2977998257*h2_1 + 0.1364194155*h2_2 + 0.1311728656*h2_3 + -0.0013606671*h2_4 + 0.1525249034*h2_5 + -0.4717965424*h2_6 + 0.2682287693*h2_7 + -0.4310618341*h2_8 + -0.2806344926*h2_9 + -0.0464595184*h2_10 + 0.9537146091*h2_11 + 0.0157826934*h2_12 + 0.2841668427*h2_13 + -0.0770657584*h2_14 + -0.3656057715*h2_15 + -0.0359445848*h2_16 + -0.0527405143*h2_17 + -0.0672465786*h2_18 + -0.0577109568*h2_19 + 0.0869172439*h2_20 + 0.4028380811*h2_21 + 0.0861429349*h2_22 + -0.0844016522*h2_23 + 0.0892697349*h2_24 + 0.2459497303*h2_25 + -1.0233064890*h2_26 + 0.5437623262*h2_27 + -0.1924086660*h2_28 + 0.5473649502*h2_29 + -0.2453559041*h2_30 + 0.3416083455*h2_31) / sqrt(1 + pow(0.2470845729 + -0.0579673387*h2_0 + -0.2977998257*h2_1 + 0.1364194155*h2_2 + 0.1311728656*h2_3 + -0.0013606671*h2_4 + 0.1525249034*h2_5 + -0.4717965424*h2_6 + 0.2682287693*h2_7 + -0.4310618341*h2_8 + -0.2806344926*h2_9 + -0.0464595184*h2_10 + 0.9537146091*h2_11 + 0.0157826934*h2_12 + 0.2841668427*h2_13 + -0.0770657584*h2_14 + -0.3656057715*h2_15 + -0.0359445848*h2_16 + -0.0527405143*h2_17 + -0.0672465786*h2_18 + -0.0577109568*h2_19 + 0.0869172439*h2_20 + 0.4028380811*h2_21 + 0.0861429349*h2_22 + -0.0844016522*h2_23 + 0.0892697349*h2_24 + 0.2459497303*h2_25 + -1.0233064890*h2_26 + 0.5437623262*h2_27 + -0.1924086660*h2_28 + 0.5473649502*h2_29 + -0.2453559041*h2_30 + 0.3416083455*h2_31, 2));

        // Output Layer: 32 -> 1 (linear)

        log10_Id = -0.1886534244 + -0.4504742026*h3_0 + -0.4664892852*h3_1 + -0.5219255090*h3_2 + -0.4709964693*h3_3 + -0.7125719190*h3_4 + -0.7202256918*h3_5 + 0.4197700620*h3_6 + 0.2815020978*h3_7 + -0.4838055074*h3_8 + -0.3797247708*h3_9 + -0.4248539209*h3_10 + -0.4403505027*h3_11 + -0.4295677543*h3_12 + -0.5971210003*h3_13 + 0.5034648180*h3_14 + -0.3055477142*h3_15 + -0.2491281778*h3_16 + -0.4343337119*h3_17 + 0.2359031588*h3_18 + -0.2290587723*h3_19 + -0.4123468697*h3_20 + 0.7011895776*h3_21 + 0.8727142811*h3_22 + -0.4180088639*h3_23 + 0.4571507871*h3_24 + -0.2754893303*h3_25 + -0.2834165096*h3_26 + 0.3977307975*h3_27 + -0.2420306951*h3_28 + 0.7303618193*h3_29 + 0.4263104200*h3_30 + -0.4280861318*h3_31;

        // Smooth tanh-based output clamping to [-12, -2]
        log10_Id = -7.0 + 5.0 * tanh((log10_Id + 7.0) / 5.0);

        Ids = pow(10, log10_Id) * (W / 10e-6);

        // Smooth VDS -> 0 transition via rational function
        vds_ratio = V(d,s) / (V(d,s) + 1e-3);
        Ids = Ids * vds_ratio;

        I(d, s) <+ Ids;
        I(g, s) <+ 1e-14 * V(g, s);
        I(b, s) <+ 1e-14 * V(b, s);
    end

endmodule
