// Working BSIM-NN Compact Model
// Network: 3 inputs -> 16 neurons (Tanh) -> 16 neurons (Tanh) -> 1 output

`include "disciplines.vams"
`include "constants.vams"

module bsim_nn(d, g, s, b);
    inout d, g, s, b;
    electrical d, g, s, b;

    parameter real L = 1e-6 from (0:inf);
    parameter real W = 10e-6 from (0:inf);

    real VGS, VDS, VBS, VGS_n, VDS_n, VBS_n, Ids, log10_Id;
    real h1_0, h2_0;
    real h1_1, h2_1;
    real h1_2, h2_2;
    real h1_3, h2_3;
    real h1_4, h2_4;
    real h1_5, h2_5;
    real h1_6, h2_6;
    real h1_7, h2_7;
    real h1_8, h2_8;
    real h1_9, h2_9;
    real h1_10, h2_10;
    real h1_11, h2_11;
    real h1_12, h2_12;
    real h1_13, h2_13;
    real h1_14, h2_14;
    real h1_15, h2_15;

    real mean_vgs = 0.500000;
    real std_vgs  = 0.297045;
    real mean_vds = 0.500000;
    real std_vds  = 0.297045;
    real mean_vbs = 0.000000;
    real std_vbs  = 0.000001;

    analog begin
        VGS = V(g, s);
        VDS = V(d, s);
        VBS = V(b, s);

        VGS_n = (VGS - mean_vgs) / std_vgs;
        VDS_n = (VDS - mean_vds) / std_vds;
        VBS_n = (VBS - mean_vbs) / std_vbs;

        // Hidden Layer 1 (Tanh)
        h1_0 = tanh(2.037550 + -0.455904*VGS_n + 1.090708*VDS_n + -0.135257*VBS_n);
        h1_1 = tanh(-0.779266 + 0.253982*VGS_n + -0.002170*VDS_n + 0.116504*VBS_n);
        h1_2 = tanh(-1.386228 + -0.922444*VGS_n + -1.518672*VDS_n + 0.508959*VBS_n);
        h1_3 = tanh(-0.746860 + 0.185613*VGS_n + -0.346842*VDS_n + 0.108056*VBS_n);
        h1_4 = tanh(-0.529710 + 1.016489*VGS_n + 0.507349*VDS_n + 0.278391*VBS_n);
        h1_5 = tanh(1.453226 + -0.081289*VGS_n + 0.125798*VDS_n + 0.085338*VBS_n);
        h1_6 = tanh(-0.015075 + -2.382586*VGS_n + -0.724487*VDS_n + -0.266006*VBS_n);
        h1_7 = tanh(0.725852 + -0.407451*VGS_n + -0.341267*VDS_n + 0.382997*VBS_n);
        h1_8 = tanh(-0.163755 + -1.235041*VGS_n + -0.892875*VDS_n + -0.163029*VBS_n);
        h1_9 = tanh(0.794021 + -1.471675*VGS_n + 1.130678*VDS_n + -0.570237*VBS_n);
        h1_10 = tanh(1.178168 + 1.184143*VGS_n + -0.619078*VDS_n + 0.445730*VBS_n);
        h1_11 = tanh(-0.506889 + 0.272046*VGS_n + -0.211646*VDS_n + 0.356774*VBS_n);
        h1_12 = tanh(1.362707 + 0.708480*VGS_n + 1.347661*VDS_n + 0.063116*VBS_n);
        h1_13 = tanh(-1.185218 + 0.263938*VGS_n + -0.586068*VDS_n + -0.156566*VBS_n);
        h1_14 = tanh(2.097947 + -0.501227*VGS_n + 1.126732*VDS_n + 0.333743*VBS_n);
        h1_15 = tanh(-1.203147 + 0.296523*VGS_n + -0.600866*VDS_n + 0.103303*VBS_n);

        // Hidden Layer 2 (Tanh)
        h2_0 = tanh(-0.826823 + -7.310419*h1_0 + 0.303584*h1_1 + 2.136951*h1_2 + 0.276311*h1_3 + -0.241632*h1_4 + -0.741678*h1_5 + 1.377066*h1_6 + -0.248338*h1_7 + 1.233915*h1_8 + 0.093676*h1_9 + -1.466947*h1_10 + 0.163025*h1_11 + -4.159468*h1_12 + 0.550448*h1_13 + -7.663648*h1_14 + 0.901029*h1_15);
        h2_1 = tanh(-0.597227 + -0.118502*h1_0 + 0.601792*h1_1 + 0.508297*h1_2 + 0.536694*h1_3 + 0.777001*h1_4 + -0.767746*h1_5 + 0.290310*h1_6 + -1.210060*h1_7 + -0.230313*h1_8 + 0.040762*h1_9 + -0.442524*h1_10 + 0.541960*h1_11 + 0.367909*h1_12 + 0.684782*h1_13 + 0.024776*h1_14 + 0.433651*h1_15);
        h2_2 = tanh(0.732175 + 0.132429*h1_0 + -0.733463*h1_1 + -0.441142*h1_2 + -0.724148*h1_3 + -0.556759*h1_4 + 0.802222*h1_5 + -0.329004*h1_6 + 0.634810*h1_7 + -0.001393*h1_8 + -0.914277*h1_9 + 0.091278*h1_10 + -0.591850*h1_11 + -0.510942*h1_12 + -0.621962*h1_13 + -0.092007*h1_14 + -0.447168*h1_15);
        h2_3 = tanh(0.728672 + 0.455091*h1_0 + -0.831671*h1_1 + -0.798628*h1_2 + -0.815857*h1_3 + -0.094371*h1_4 + 0.514396*h1_5 + -0.444464*h1_6 + 0.422737*h1_7 + -0.349649*h1_8 + -0.167635*h1_9 + 0.828431*h1_10 + -0.593753*h1_11 + 0.390266*h1_12 + -0.872419*h1_13 + 0.174019*h1_14 + -1.274371*h1_15);
        h2_4 = tanh(0.439122 + 0.362004*h1_0 + -0.699462*h1_1 + -0.232380*h1_2 + -0.417813*h1_3 + -0.658822*h1_4 + 0.936841*h1_5 + -0.120195*h1_6 + 0.639192*h1_7 + -0.034120*h1_8 + -1.062652*h1_9 + 0.846758*h1_10 + -0.554507*h1_11 + -0.108504*h1_12 + -0.736011*h1_13 + 0.102439*h1_14 + -0.731263*h1_15);
        h2_5 = tanh(-0.215544 + 3.233325*h1_0 + 0.263648*h1_1 + 0.580995*h1_2 + 0.228096*h1_3 + 0.371531*h1_4 + -0.362384*h1_5 + -0.445599*h1_6 + -0.221754*h1_7 + -0.332526*h1_8 + -1.719981*h1_9 + 2.280737*h1_10 + 0.000308*h1_11 + 1.384174*h1_12 + 0.347163*h1_13 + 3.612494*h1_14 + 0.560388*h1_15);
        h2_6 = tanh(0.391127 + 0.093903*h1_0 + -0.672384*h1_1 + -0.303218*h1_2 + -0.768843*h1_3 + -0.507695*h1_4 + 0.667166*h1_5 + -0.196380*h1_6 + 1.220956*h1_7 + 0.201569*h1_8 + -0.409055*h1_9 + 0.465572*h1_10 + -0.560082*h1_11 + -0.320706*h1_12 + -0.540439*h1_13 + -0.471435*h1_14 + -0.613622*h1_15);
        h2_7 = tanh(-0.143064 + -0.066650*h1_0 + -0.259392*h1_1 + 0.036193*h1_2 + -0.707469*h1_3 + -0.613857*h1_4 + 0.373567*h1_5 + 1.337562*h1_6 + 0.152251*h1_7 + 0.876491*h1_8 + 2.046440*h1_9 + -2.203988*h1_10 + -0.444294*h1_11 + -1.199542*h1_12 + -0.400722*h1_13 + -0.062186*h1_14 + -0.629681*h1_15);
        h2_8 = tanh(0.364999 + 0.566778*h1_0 + -0.388005*h1_1 + -0.731879*h1_2 + -0.880642*h1_3 + -0.054839*h1_4 + 0.734906*h1_5 + -0.274535*h1_6 + 0.581529*h1_7 + -0.600163*h1_8 + -0.018528*h1_9 + 0.824120*h1_10 + -0.364207*h1_11 + 0.520518*h1_12 + -0.978601*h1_13 + 0.089709*h1_14 + -1.436084*h1_15);
        h2_9 = tanh(0.298717 + -0.428965*h1_0 + -0.402622*h1_1 + -0.432483*h1_2 + 0.126689*h1_3 + -0.879094*h1_4 + 0.235448*h1_5 + 0.287236*h1_6 + 0.871509*h1_7 + 0.339699*h1_8 + 0.832547*h1_9 + -0.227106*h1_10 + -0.205715*h1_11 + 0.268917*h1_12 + -0.178600*h1_13 + -0.740318*h1_14 + -0.426593*h1_15);
        h2_10 = tanh(-0.406810 + -0.192687*h1_0 + 0.876528*h1_1 + 0.580106*h1_2 + 0.595988*h1_3 + 0.347932*h1_4 + -1.004120*h1_5 + -0.064440*h1_6 + -0.703553*h1_7 + -0.000693*h1_8 + 0.783420*h1_9 + -0.205311*h1_10 + 0.582828*h1_11 + 0.324400*h1_12 + 0.329609*h1_13 + 0.105190*h1_14 + 0.318540*h1_15);
        h2_11 = tanh(0.552761 + 0.451957*h1_0 + -0.657118*h1_1 + -0.717676*h1_2 + -0.955160*h1_3 + -0.046179*h1_4 + 0.503996*h1_5 + -0.482942*h1_6 + 0.506345*h1_7 + -0.475774*h1_8 + 0.046517*h1_9 + 0.565705*h1_10 + -0.561860*h1_11 + 0.584327*h1_12 + -0.988253*h1_13 + 0.094371*h1_14 + -1.549082*h1_15);
        h2_12 = tanh(0.401971 + 0.507358*h1_0 + -0.803771*h1_1 + -0.610453*h1_2 + -0.641137*h1_3 + 0.192489*h1_4 + 0.597115*h1_5 + -0.418758*h1_6 + 0.422012*h1_7 + -0.454153*h1_8 + -0.135207*h1_9 + 0.715974*h1_10 + -0.496006*h1_11 + 0.420437*h1_12 + -1.068675*h1_13 + 0.213917*h1_14 + -1.410047*h1_15);
        h2_13 = tanh(-0.725022 + -0.264782*h1_0 + 0.730793*h1_1 + 0.832996*h1_2 + 0.654508*h1_3 + -0.101894*h1_4 + -0.624050*h1_5 + 0.407713*h1_6 + -0.725840*h1_7 + 0.227570*h1_8 + -0.033027*h1_9 + -0.679071*h1_10 + 0.305307*h1_11 + -0.410073*h1_12 + 0.676000*h1_13 + -0.490316*h1_14 + 1.274144*h1_15);
        h2_14 = tanh(-0.081340 + 1.465609*h1_0 + 0.068873*h1_1 + 0.376105*h1_2 + 0.121702*h1_3 + -0.200156*h1_4 + -0.318116*h1_5 + -0.337390*h1_6 + -0.120469*h1_7 + -0.643045*h1_8 + -1.990992*h1_9 + 1.043455*h1_10 + 0.123884*h1_11 + 1.093387*h1_12 + 0.344977*h1_13 + 1.730875*h1_14 + 0.438656*h1_15);
        h2_15 = tanh(-0.739839 + -0.188294*h1_0 + 0.859956*h1_1 + 0.253733*h1_2 + 0.578276*h1_3 + 0.126254*h1_4 + -0.700826*h1_5 + 0.685341*h1_6 + -0.572052*h1_7 + -0.038148*h1_8 + 0.893334*h1_9 + 0.586402*h1_10 + 0.515778*h1_11 + 0.489358*h1_12 + 0.745790*h1_13 + 0.157961*h1_14 + 0.585215*h1_15);

        // Output Layer
        log10_Id = -0.519047 + -4.135955*h2_0 + 1.028293*h2_1 + -0.958738*h2_2 + -0.928836*h2_3 + -1.013553*h2_4 + 1.851035*h2_5 + -1.033814*h2_6 + -0.734435*h2_7 + -1.102953*h2_8 + -0.561967*h2_9 + 1.177848*h2_10 + -1.030224*h2_11 + -1.051660*h2_12 + 0.959811*h2_13 + 0.865652*h2_14 + 1.019517*h2_15;

        // Clamp output
        log10_Id = (log10_Id < -12) ? -12 : ((log10_Id > -3) ? -3 : log10_Id);
        Ids = pow(10, log10_Id) * (W / 10e-6);

        if (Ids < 1e-12) Ids = 1e-12;
        if (Ids > 1e-3) Ids = 1e-3;
        if (VDS == 0) Ids = 0;

        I(d, s) <+ Ids;
        I(g, s) <+ 0;
        I(b, s) <+ 0;
    end

endmodule
