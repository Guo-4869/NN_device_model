// ANN-based MOSFET Model - Physics-Aware Design
// Vgs features: linear, square, exponential
// Vds features: linear, square, saturation
// Generated from PyTorch training

`include "disciplines.vams"

module ann_improved(d, g, s);
    inout d, g, s;
    electrical d, g, s;

    parameter real w = 10e-6;
    parameter real l = 10e-6;

    real Vgs, Vds, Ids;
    real logIds;
    real Vgs_n, Vds_n;
    real out;

    // Normalization parameters
    real mean_vgs = 1.262930;
    real scale_vgs = 0.824712;
    real mean_vds = 0.994081;
    real scale_vds = 0.821468;
    real mean_logids = -5.865475;
    real scale_logids = 3.700235;

    // Neural network weights
    real w1[12][6];
    real b1[12];
    real w2[12][12];
    real b2[12];
    real w3[1][12];
    real b3;

    real h1[12];
    real h2[12];
    integer i, j;

    // Initialize weights (in analog initial block)
    analog initial begin
        w1[0][0] = 0.13658580;
        w1[0][1] = 0.61688924;
        w1[0][2] = -0.39857560;
        w1[0][3] = 0.25645253;
        w1[0][4] = 0.17805561;
        w1[0][5] = -0.12547481;
        w1[1][0] = -0.07004214;
        w1[1][1] = -0.80226147;
        w1[1][2] = -0.38406679;
        w1[1][3] = -0.25395998;
        w1[1][4] = -0.13925891;
        w1[1][5] = -0.23240934;
        w1[2][0] = 0.36491856;
        w1[2][1] = -0.34975085;
        w1[2][2] = 0.54869097;
        w1[2][3] = -0.18158844;
        w1[2][4] = 0.00670770;
        w1[2][5] = 0.03410294;
        w1[3][0] = 0.37972659;
        w1[3][1] = -0.49492165;
        w1[3][2] = 0.26079208;
        w1[3][3] = -0.06613246;
        w1[3][4] = 0.19593871;
        w1[3][5] = 0.22095436;
        w1[4][0] = 0.02529345;
        w1[4][1] = -0.10941961;
        w1[4][2] = 0.41641441;
        w1[4][3] = -0.13311231;
        w1[4][4] = 0.07819229;
        w1[4][5] = 0.06349706;
        w1[5][0] = 0.18565166;
        w1[5][1] = -0.38630959;
        w1[5][2] = 0.45328671;
        w1[5][3] = 0.30674860;
        w1[5][4] = 0.38997719;
        w1[5][5] = 0.06913992;
        w1[6][0] = 0.11829375;
        w1[6][1] = -0.35567445;
        w1[6][2] = -0.30471238;
        w1[6][3] = -0.16857009;
        w1[6][4] = -0.27568766;
        w1[6][5] = 0.01413104;
        w1[7][0] = 0.22531760;
        w1[7][1] = -0.08890630;
        w1[7][2] = 0.41087562;
        w1[7][3] = -0.03429933;
        w1[7][4] = 0.10782520;
        w1[7][5] = -0.21157393;
        w1[8][0] = 0.18590252;
        w1[8][1] = 0.08580282;
        w1[8][2] = 0.37041563;
        w1[8][3] = 0.36828426;
        w1[8][4] = 0.25672367;
        w1[8][5] = -0.27076232;
        w1[9][0] = -0.61088896;
        w1[9][1] = 0.57342380;
        w1[9][2] = -0.25540078;
        w1[9][3] = 0.31554133;
        w1[9][4] = -0.59570616;
        w1[9][5] = -0.27966437;
        w1[10][0] = 0.19763888;
        w1[10][1] = -0.52192193;
        w1[10][2] = -0.22276963;
        w1[10][3] = -0.22468705;
        w1[10][4] = -0.24953532;
        w1[10][5] = -0.10625275;
        w1[11][0] = 0.11198762;
        w1[11][1] = -0.11228754;
        w1[11][2] = 0.35222900;
        w1[11][3] = 0.36582768;
        w1[11][4] = -0.26739591;
        w1[11][5] = 0.43783206;

        b1[0] = -0.04724667;
        b1[1] = -0.33281824;
        b1[2] = 0.57389599;
        b1[3] = 0.51783329;
        b1[4] = 0.30558077;
        b1[5] = 0.38042337;
        b1[6] = -0.48804367;
        b1[7] = 0.02936850;
        b1[8] = 0.28352073;
        b1[9] = -0.05261544;
        b1[10] = 0.17366658;
        b1[11] = 0.41157639;

        w2[0][0] = 0.29056704;
        w2[0][1] = -0.36341000;
        w2[0][2] = -0.32280970;
        w2[0][3] = 0.05790246;
        w2[0][4] = -0.28050661;
        w2[0][5] = -0.41646671;
        w2[0][6] = 0.08647211;
        w2[0][7] = -0.23900539;
        w2[0][8] = -0.24505158;
        w2[0][9] = 0.13572825;
        w2[0][10] = -0.01626666;
        w2[0][11] = -0.40220326;
        w2[1][0] = 0.36958918;
        w2[1][1] = -0.37469679;
        w2[1][2] = 0.03569649;
        w2[1][3] = 0.04140031;
        w2[1][4] = 0.10920016;
        w2[1][5] = -0.02802959;
        w2[1][6] = -0.39065489;
        w2[1][7] = 0.09620386;
        w2[1][8] = 0.39186218;
        w2[1][9] = 0.03139356;
        w2[1][10] = -0.29620224;
        w2[1][11] = 0.21775657;
        w2[2][0] = -0.06344767;
        w2[2][1] = 0.11902740;
        w2[2][2] = 0.53771865;
        w2[2][3] = 0.34696522;
        w2[2][4] = -0.06211392;
        w2[2][5] = 0.31610954;
        w2[2][6] = 0.11571448;
        w2[2][7] = 0.34494260;
        w2[2][8] = -0.10625232;
        w2[2][9] = -0.32601243;
        w2[2][10] = 0.26989257;
        w2[2][11] = 0.44414720;
        w2[3][0] = 0.00626851;
        w2[3][1] = 0.13944504;
        w2[3][2] = -0.08027342;
        w2[3][3] = -0.23684101;
        w2[3][4] = 0.32825544;
        w2[3][5] = 0.25333634;
        w2[3][6] = 0.16772185;
        w2[3][7] = 0.00730755;
        w2[3][8] = -0.02670201;
        w2[3][9] = 0.21185076;
        w2[3][10] = -0.04402781;
        w2[3][11] = 0.18059556;
        w2[4][0] = 0.14479069;
        w2[4][1] = -0.12194108;
        w2[4][2] = -0.19742306;
        w2[4][3] = -0.26449513;
        w2[4][4] = -0.36600813;
        w2[4][5] = -0.28703648;
        w2[4][6] = -0.09068165;
        w2[4][7] = -0.41526538;
        w2[4][8] = -0.02573382;
        w2[4][9] = 0.06161780;
        w2[4][10] = -0.23486792;
        w2[4][11] = -0.39435768;
        w2[5][0] = 0.22036985;
        w2[5][1] = 0.04034198;
        w2[5][2] = 0.12667683;
        w2[5][3] = -0.23462865;
        w2[5][4] = 0.26311791;
        w2[5][5] = 0.30738595;
        w2[5][6] = 0.09977136;
        w2[5][7] = 0.30586481;
        w2[5][8] = -0.33102059;
        w2[5][9] = 0.17323504;
        w2[5][10] = -0.05855359;
        w2[5][11] = 0.01765750;
        w2[6][0] = 0.05853230;
        w2[6][1] = -0.12052372;
        w2[6][2] = -0.44225267;
        w2[6][3] = -0.02282599;
        w2[6][4] = 0.04790937;
        w2[6][5] = -0.41848254;
        w2[6][6] = -0.05177479;
        w2[6][7] = -0.24564175;
        w2[6][8] = -0.17783304;
        w2[6][9] = 0.31008831;
        w2[6][10] = -0.07136855;
        w2[6][11] = -0.25475878;
        w2[7][0] = 0.03558794;
        w2[7][1] = -0.47887349;
        w2[7][2] = -0.13898671;
        w2[7][3] = -0.21339488;
        w2[7][4] = 0.14811648;
        w2[7][5] = -0.17612192;
        w2[7][6] = -0.24957922;
        w2[7][7] = 0.21577719;
        w2[7][8] = 0.37063885;
        w2[7][9] = -0.03645833;
        w2[7][10] = -0.13670218;
        w2[7][11] = 0.13327581;
        w2[8][0] = 0.04013920;
        w2[8][1] = -0.16865276;
        w2[8][2] = -0.00766072;
        w2[8][3] = 0.13433526;
        w2[8][4] = -0.13436107;
        w2[8][5] = 0.11901689;
        w2[8][6] = -0.20369032;
        w2[8][7] = 0.08829887;
        w2[8][8] = -0.09629618;
        w2[8][9] = -0.09392859;
        w2[8][10] = -0.16330072;
        w2[8][11] = 0.27395201;
        w2[9][0] = 0.03356075;
        w2[9][1] = -0.54707569;
        w2[9][2] = 0.28928602;
        w2[9][3] = -0.09183893;
        w2[9][4] = 0.04307210;
        w2[9][5] = -0.15732297;
        w2[9][6] = -0.04159785;
        w2[9][7] = 0.40198475;
        w2[9][8] = 0.53160995;
        w2[9][9] = -0.22448634;
        w2[9][10] = -0.37183267;
        w2[9][11] = 0.41449121;
        w2[10][0] = -0.22247604;
        w2[10][1] = -0.00965499;
        w2[10][2] = 0.21091951;
        w2[10][3] = -0.09759515;
        w2[10][4] = -0.03358214;
        w2[10][5] = -0.05129596;
        w2[10][6] = 0.01548345;
        w2[10][7] = -0.04290922;
        w2[10][8] = 0.10555945;
        w2[10][9] = 0.14181106;
        w2[10][10] = -0.20634954;
        w2[10][11] = 0.23331068;
        w2[11][0] = -0.38015512;
        w2[11][1] = 0.33530444;
        w2[11][2] = 0.01232154;
        w2[11][3] = 0.47640583;
        w2[11][4] = 0.21540235;
        w2[11][5] = -0.06709766;
        w2[11][6] = -0.23542768;
        w2[11][7] = 0.44524419;
        w2[11][8] = 0.37412435;
        w2[11][9] = -0.51099533;
        w2[11][10] = 0.10203409;
        w2[11][11] = 0.45111573;

        b2[0] = -0.17084041;
        b2[1] = 0.20975265;
        b2[2] = 0.33843690;
        b2[3] = 0.05409736;
        b2[4] = -0.29137796;
        b2[5] = 0.06339744;
        b2[6] = -0.30956945;
        b2[7] = 0.11118300;
        b2[8] = -0.13330355;
        b2[9] = 0.11676528;
        b2[10] = -0.19153973;
        b2[11] = 0.21476723;

        w3[0][0] = -0.18222310;
        w3[0][1] = -0.11355259;
        w3[0][2] = 0.35892293;
        w3[0][3] = 0.31254578;
        w3[0][4] = -0.23052342;
        w3[0][5] = 0.11225103;
        w3[0][6] = -0.34351027;
        w3[0][7] = -0.20657140;
        w3[0][8] = 0.16592360;
        w3[0][9] = -0.13471195;
        w3[0][10] = 0.08075178;
        w3[0][11] = 0.28870440;

        b3 = -0.09883424;
    end

    analog begin
        // Get input voltages
        Vgs = V(g, s);
        Vds = V(d, s);

        // Normalize inputs
        Vgs_n = (Vgs - mean_vgs) / scale_vgs;
        Vds_n = (Vds - mean_vds) / scale_vds;

        // 物理启发的特征提取
        // Vgs 特征: 线性, 平方, 指数
        real vgs_lin = Vgs_n;
        real vgs_sq = Vgs_n * Vgs_n;
        real vgs_exp = exp(0.755309 * Vgs_n) - 1.0;

        // Vds 特征: 线性, 平方, 饱和
        real vds_lin = Vds_n;
        real vds_sq = Vds_n * Vds_n;
        real vds_sat = tanh(1.097574 * Vds_n);

        // Input features
        real x[6];
        x[0] = vgs_lin;
        x[1] = vgs_sq;
        x[2] = vgs_exp;
        x[3] = vds_lin;
        x[4] = vds_sq;
        x[5] = vds_sat;

        // Hidden layer 1
        for (i = 0; i < 12; i = i + 1) begin
            h1[i] = b1[i];
            for (j = 0; j < 6; j = j + 1)
                h1[i] = h1[i] + w1[i][j] * x[j];
            h1[i] = tanh(h1[i]);
        end

        // Hidden layer 2
        for (i = 0; i < 12; i = i + 1) begin
            h2[i] = b2[i];
            for (j = 0; j < 12; j = j + 1)
                h2[i] = h2[i] + w2[i][j] * h1[j];
            h2[i] = tanh(h2[i]);
        end

        // Output layer
        out = b3;
        for (j = 0; j < 12; j = j + 1)
            out = out + w3[0][j] * h2[j];

        // Denormalize
        logIds = out * scale_logids + mean_logids;
        Ids = pow(10, logIds) * (w / l);

        // Output current
        I(d, s) <+ Ids;
        I(g, s) <+ 0;
    end
endmodule
