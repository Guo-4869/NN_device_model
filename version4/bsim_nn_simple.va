// ============================================================
// BSIM-NN: Simplified Example Verilog-A Model
// ============================================================

`include "disciplines.vams"
`include "constants.vams"

module bsim_nn_simple(d, g, s);
    inout d, g, s;
    electrical d, g, s;

    // Geometry parameters
    parameter real w = 10e-6;
    parameter real l = 1e-6;

    // Internal variables
    real Vgs, Vds, Ids;
    real h1, h2, h3, h4, h5, h6, h7, h8;
    real h9, h10, h11, h12, h13, h14, h15, h16;
    real log10_Id;

    // Input normalization parameters
    real mean_vgs = 0.5;
    real scale_vgs = 0.3;
    real mean_vds = 0.5;
    real scale_vds = 0.3;
    real Vgs_n, Vds_n;

    analog begin
        // Read voltages
        Vgs = V(g, s);
        Vds = V(d, s);

        // Normalize inputs
        Vgs_n = (Vgs - mean_vgs) / scale_vgs;
        Vds_n = (Vds - mean_vds) / scale_vds;

        // Hidden layer 1 (ISRU inline: x / sqrt(1 + x^2))
        h1 = ( 0.5*Vgs_n + -0.2*Vds_n + 0.1) / `sqrt(1.0 + (0.5*Vgs_n + -0.2*Vds_n + 0.1)*(0.5*Vgs_n + -0.2*Vds_n + 0.1));
        h2 = ( 0.3*Vgs_n + -0.1*Vds_n + 0.0) / `sqrt(1.0 + (0.3*Vgs_n + -0.1*Vds_n + 0.0)*(0.3*Vgs_n + -0.1*Vds_n + 0.0));
        h3 = (-0.4*Vgs_n +  0.3*Vds_n + -0.1) / `sqrt(1.0 + (-0.4*Vgs_n +  0.3*Vds_n + -0.1)*(-0.4*Vgs_n +  0.3*Vds_n + -0.1));
        h4 = (-0.2*Vgs_n +  0.5*Vds_n + -0.2) / `sqrt(1.0 + (-0.2*Vgs_n +  0.5*Vds_n + -0.2)*(-0.2*Vgs_n +  0.5*Vds_n + -0.2));
        h5 = ( 0.1*Vgs_n + -0.3*Vds_n + 0.2) / `sqrt(1.0 + (0.1*Vgs_n + -0.3*Vds_n + 0.2)*(0.1*Vgs_n + -0.3*Vds_n + 0.2));
        h6 = ( 0.2*Vgs_n +  0.1*Vds_n + -0.1) / `sqrt(1.0 + (0.2*Vgs_n +  0.1*Vds_n + -0.1)*(0.2*Vgs_n +  0.1*Vds_n + -0.1));
        h7 = (-0.1*Vgs_n + -0.2*Vds_n + 0.1) / `sqrt(1.0 + (-0.1*Vgs_n + -0.2*Vds_n + 0.1)*(-0.1*Vgs_n + -0.2*Vds_n + 0.1));
        h8 = ( 0.0*Vgs_n +  0.2*Vds_n + 0.0) / `sqrt(1.0 + (0.0*Vgs_n +  0.2*Vds_n + 0.0)*(0.0*Vgs_n +  0.2*Vds_n + 0.0));

        // Hidden layer 2 (ISRU inline)
        h9  = ( 0.3*h1 + -0.1*h2 +  0.2*h3 + -0.1*h4 +  0.1*h5 + -0.2*h6 +  0.1*h7 + -0.1*h8 + 0.0) / `sqrt(1.0 + (0.3*h1 + -0.1*h2 +  0.2*h3 + -0.1*h4 +  0.1*h5 + -0.2*h6 +  0.1*h7 + -0.1*h8 + 0.0)*(0.3*h1 + -0.1*h2 +  0.2*h3 + -0.1*h4 +  0.1*h5 + -0.2*h6 +  0.1*h7 + -0.1*h8 + 0.0));
        h10 = ( 0.2*h1 +  0.1*h2 + -0.1*h3 +  0.2*h4 + -0.2*h5 +  0.1*h6 + -0.1*h7 +  0.1*h8 + 0.0) / `sqrt(1.0 + (0.2*h1 +  0.1*h2 + -0.1*h3 +  0.2*h4 + -0.2*h5 +  0.1*h6 + -0.1*h7 +  0.1*h8 + 0.0)*(0.2*h1 +  0.1*h2 + -0.1*h3 +  0.2*h4 + -0.2*h5 +  0.1*h6 + -0.1*h7 +  0.1*h8 + 0.0));
        h11 = (-0.1*h1 +  0.3*h2 +  0.1*h3 + -0.2*h4 +  0.1*h5 +  0.0*h6 + -0.2*h7 +  0.2*h8 + 0.0) / `sqrt(1.0 + (-0.1*h1 +  0.3*h2 +  0.1*h3 + -0.2*h4 +  0.1*h5 +  0.0*h6 + -0.2*h7 +  0.2*h8 + 0.0)*(-0.1*h1 +  0.3*h2 +  0.1*h3 + -0.2*h4 +  0.1*h5 +  0.0*h6 + -0.2*h7 +  0.2*h8 + 0.0));
        h12 = ( 0.1*h1 + -0.2*h2 +  0.0*h3 +  0.3*h4 + -0.1*h5 +  0.2*h6 +  0.1*h7 + -0.2*h8 + 0.0) / `sqrt(1.0 + (0.1*h1 + -0.2*h2 +  0.0*h3 +  0.3*h4 + -0.1*h5 +  0.2*h6 +  0.1*h7 + -0.2*h8 + 0.0)*(0.1*h1 + -0.2*h2 +  0.0*h3 +  0.3*h4 + -0.1*h5 +  0.2*h6 +  0.1*h7 + -0.2*h8 + 0.0));
        h13 = (-0.2*h1 +  0.0*h2 + -0.1*h3 +  0.1*h4 +  0.2*h5 + -0.1*h6 +  0.0*h7 +  0.3*h8 + 0.0) / `sqrt(1.0 + (-0.2*h1 +  0.0*h2 + -0.1*h3 +  0.1*h4 +  0.2*h5 + -0.1*h6 +  0.0*h7 +  0.3*h8 + 0.0)*(-0.2*h1 +  0.0*h2 + -0.1*h3 +  0.1*h4 +  0.2*h5 + -0.1*h6 +  0.0*h7 +  0.3*h8 + 0.0));
        h14 = ( 0.1*h1 +  0.2*h2 + -0.2*h3 +  0.0*h4 + -0.1*h5 +  0.3*h6 +  0.1*h7 + -0.1*h8 + 0.0) / `sqrt(1.0 + (0.1*h1 +  0.2*h2 + -0.2*h3 +  0.0*h4 + -0.1*h5 +  0.3*h6 +  0.1*h7 + -0.1*h8 + 0.0)*(0.1*h1 +  0.2*h2 + -0.2*h3 +  0.0*h4 + -0.1*h5 +  0.3*h6 +  0.1*h7 + -0.1*h8 + 0.0));
        h15 = (-0.1*h1 + -0.1*h2 +  0.1*h3 + -0.1*h4 +  0.2*h5 + -0.2*h6 +  0.3*h7 +  0.0*h8 + 0.0) / `sqrt(1.0 + (-0.1*h1 + -0.1*h2 +  0.1*h3 + -0.1*h4 +  0.2*h5 + -0.2*h6 +  0.3*h7 +  0.0*h8 + 0.0)*(-0.1*h1 + -0.1*h2 +  0.1*h3 + -0.1*h4 +  0.2*h5 + -0.2*h6 +  0.3*h7 +  0.0*h8 + 0.0));
        h16 = ( 0.0*h1 +  0.1*h2 + -0.2*h3 +  0.1*h4 + -0.1*h5 +  0.0*h6 + -0.1*h7 +  0.2*h8 + 0.0) / `sqrt(1.0 + (0.0*h1 +  0.1*h2 + -0.2*h3 +  0.1*h4 + -0.1*h5 +  0.0*h6 + -0.1*h7 +  0.2*h8 + 0.0)*(0.0*h1 +  0.1*h2 + -0.2*h3 +  0.1*h4 + -0.1*h5 +  0.0*h6 + -0.1*h7 +  0.2*h8 + 0.0));

        // Output layer
        log10_Id = -6.0
            + 0.2*h9  + 0.1*h10 + -0.1*h11 + 0.2*h12
            + -0.1*h13 + 0.1*h14 + -0.2*h15 + 0.1*h16;

        // Clamp and convert to linear current
        log10_Id = (log10_Id < -8) ? -8 : ((log10_Id > -3) ? -3 : log10_Id);
        Ids = pow(10, log10_Id) * (w / 10e-6);
        if (Ids < 1e-12) Ids = 1e-12;
        if (Ids > 1e-3) Ids = 1e-3;
        if (Vds == 0) Ids = 0;

        // Output current
        I(d, s) <+ Ids;
        I(g, s) <+ 0;
    end

endmodule
