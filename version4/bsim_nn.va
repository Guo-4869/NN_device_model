// ============================================================
// BSIM-NN: Neural Network Based MOSFET Compact Model
// ============================================================
// Reference: C.T. Tung et al., IEEE TED, 2023
//           "A SPICE-compatible Neural Network Compact Model"
// ============================================================
// Network Architecture:
//   Input Layer: 3 nodes
//   Hidden Layer 1: 32 nodes (ISRU)
//   Hidden Layer 2: 32 nodes (ISRU)
//   Output Layer: 1 node (linear)
// ============================================================
// Activation: ISRU(x) = x / sqrt(1 + x^2) (inline expansion)
// Output: log10(ID) = f(VGS, VDS, VBS)
// ============================================================

`include "disciplines.vams"
`include "constants.vams"

module bsim_nn(d, g, s, b);
    inout d, g, s, b;
    electrical d, g, s, b;

    // ==============================================
    // Geometry Parameters
    // ==============================================
    parameter real L = 1e-6 from (0:inf);   // Channel length (m)
    parameter real W = 10e-6 from (0:inf);  // Channel width (m)
    parameter real NFIN = 1;                // Number of fins

    // ==============================================
    // Internal Variables
    // ==============================================
    real VGS, VDS, VBS;
    real Ids, Igs, Ibs;
    real log10_Id;
    real gm, gds;

    // ==============================================
    // Input Normalization (Z-score)
    // ==============================================
    real mean_vgs = 0.49999946;
    real std_vgs  = 0.29450861;
    real mean_vds = 0.50000000;
    real std_vds  = 0.29450849;
    real mean_vbs = 0.00000000;
    real std_vbs  = 0.00000100;

    real VGS_n, VDS_n, VBS_n;

    // ==============================================
    // Hidden Layer 1: 32 neurons (ISRU)
    // ==============================================
    real h1_0, h1_1, h1_2, h1_3, h1_4, h1_5, h1_6, h1_7, h1_8, h1_9, h1_10, h1_11, h1_12, h1_13, h1_14, h1_15, h1_16, h1_17, h1_18, h1_19, h1_20, h1_21, h1_22, h1_23, h1_24, h1_25, h1_26, h1_27, h1_28, h1_29, h1_30, h1_31;

    // ==============================================
    // Hidden Layer 2: 32 neurons (ISRU)
    // ==============================================
    real h2_0, h2_1, h2_2, h2_3, h2_4, h2_5, h2_6, h2_7, h2_8, h2_9, h2_10, h2_11, h2_12, h2_13, h2_14, h2_15, h2_16, h2_17, h2_18, h2_19, h2_20, h2_21, h2_22, h2_23, h2_24, h2_25, h2_26, h2_27, h2_28, h2_29, h2_30, h2_31;

    // ==============================================
    // Output Layer
    // ==============================================
    real log10_Id_nn;

    // ==============================================
    // Forward Propagation
    // ==============================================

    // Step 1: Normalize inputs
    VGS_n = (VGS - mean_vgs) / std_vgs;
    VDS_n = (VDS - mean_vds) / std_vds;
    VBS_n = (VBS - mean_vbs) / std_vbs;

    // Step 2: Hidden Layer 1 (ISRU activation inline)
        h1_0 = (0.1784937382 + -0.2850520909*VGS_n + 0.4396469891*VDS_n + -0.0000000000*VBS_n / `sqrt(1.0 + (0.1784937382 + -0.2850520909*VGS_n + 0.4396469891*VDS_n + -0.0000000000*VBS_n)*(0.1784937382 + -0.2850520909*VGS_n + 0.4396469891*VDS_n + -0.0000000000*VBS_n)));
        h1_1 = (0.6726036072 + -0.0660927966*VGS_n + -0.0605161525*VDS_n + -0.0000000000*VBS_n / `sqrt(1.0 + (0.6726036072 + -0.0660927966*VGS_n + -0.0605161525*VDS_n + -0.0000000000*VBS_n)*(0.6726036072 + -0.0660927966*VGS_n + -0.0605161525*VDS_n + -0.0000000000*VBS_n)));
        h1_2 = (0.2966895998 + -0.8735349774*VGS_n + -0.0662584603*VDS_n + -0.0000000000*VBS_n / `sqrt(1.0 + (0.2966895998 + -0.8735349774*VGS_n + -0.0662584603*VDS_n + -0.0000000000*VBS_n)*(0.2966895998 + -0.8735349774*VGS_n + -0.0662584603*VDS_n + -0.0000000000*VBS_n)));
        h1_3 = (0.5892227292 + -0.0260180943*VGS_n + -0.0236529820*VDS_n + -0.0000000000*VBS_n / `sqrt(1.0 + (0.5892227292 + -0.0260180943*VGS_n + -0.0236529820*VDS_n + -0.0000000000*VBS_n)*(0.5892227292 + -0.0260180943*VGS_n + -0.0236529820*VDS_n + -0.0000000000*VBS_n)));
        h1_4 = (0.0299265310 + 1.6854467392*VGS_n + -0.0208031945*VDS_n + -0.0000000000*VBS_n / `sqrt(1.0 + (0.0299265310 + 1.6854467392*VGS_n + -0.0208031945*VDS_n + -0.0000000000*VBS_n)*(0.0299265310 + 1.6854467392*VGS_n + -0.0208031945*VDS_n + -0.0000000000*VBS_n)));
        h1_5 = (-0.6530466676 + 0.2515325844*VGS_n + -0.4980531335*VDS_n + -0.0000000000*VBS_n / `sqrt(1.0 + (-0.6530466676 + 0.2515325844*VGS_n + -0.4980531335*VDS_n + -0.0000000000*VBS_n)*(-0.6530466676 + 0.2515325844*VGS_n + -0.4980531335*VDS_n + -0.0000000000*VBS_n)));
        h1_6 = (0.3869090974 + 0.1680120081*VGS_n + 0.6941106915*VDS_n + -0.0000000000*VBS_n / `sqrt(1.0 + (0.3869090974 + 0.1680120081*VGS_n + 0.6941106915*VDS_n + -0.0000000000*VBS_n)*(0.3869090974 + 0.1680120081*VGS_n + 0.6941106915*VDS_n + -0.0000000000*VBS_n)));
        h1_7 = (0.7039474845 + 0.3058185279*VGS_n + -0.3799398541*VDS_n + -0.0000000000*VBS_n / `sqrt(1.0 + (0.7039474845 + 0.3058185279*VGS_n + -0.3799398541*VDS_n + -0.0000000000*VBS_n)*(0.7039474845 + 0.3058185279*VGS_n + -0.3799398541*VDS_n + -0.0000000000*VBS_n)));
        h1_8 = (0.8434940577 + 0.4973379970*VGS_n + 0.0699036121*VDS_n + 0.0000000000*VBS_n / `sqrt(1.0 + (0.8434940577 + 0.4973379970*VGS_n + 0.0699036121*VDS_n + 0.0000000000*VBS_n)*(0.8434940577 + 0.4973379970*VGS_n + 0.0699036121*VDS_n + 0.0000000000*VBS_n)));
        h1_9 = (-0.3120607734 + 0.0281665679*VGS_n + -0.1026073918*VDS_n + 0.0000000000*VBS_n / `sqrt(1.0 + (-0.3120607734 + 0.0281665679*VGS_n + -0.1026073918*VDS_n + 0.0000000000*VBS_n)*(-0.3120607734 + 0.0281665679*VGS_n + -0.1026073918*VDS_n + 0.0000000000*VBS_n)));
        h1_10 = (0.9157930017 + 0.5473627448*VGS_n + 0.1017671749*VDS_n + -0.0000000000*VBS_n / `sqrt(1.0 + (0.9157930017 + 0.5473627448*VGS_n + 0.1017671749*VDS_n + -0.0000000000*VBS_n)*(0.9157930017 + 0.5473627448*VGS_n + 0.1017671749*VDS_n + -0.0000000000*VBS_n)));
        h1_11 = (0.2281908393 + -0.0592073202*VGS_n + -0.0680729076*VDS_n + 0.0000000000*VBS_n / `sqrt(1.0 + (0.2281908393 + -0.0592073202*VGS_n + -0.0680729076*VDS_n + 0.0000000000*VBS_n)*(0.2281908393 + -0.0592073202*VGS_n + -0.0680729076*VDS_n + 0.0000000000*VBS_n)));
        h1_12 = (0.1319639683 + -0.0164998751*VGS_n + 0.0702233911*VDS_n + 0.0000000000*VBS_n / `sqrt(1.0 + (0.1319639683 + -0.0164998751*VGS_n + 0.0702233911*VDS_n + 0.0000000000*VBS_n)*(0.1319639683 + -0.0164998751*VGS_n + 0.0702233911*VDS_n + 0.0000000000*VBS_n)));
        h1_13 = (0.1241293997 + 0.2868251503*VGS_n + -0.0270901620*VDS_n + 0.0000000000*VBS_n / `sqrt(1.0 + (0.1241293997 + 0.2868251503*VGS_n + -0.0270901620*VDS_n + 0.0000000000*VBS_n)*(0.1241293997 + 0.2868251503*VGS_n + -0.0270901620*VDS_n + 0.0000000000*VBS_n)));
        h1_14 = (0.0806543827 + 0.7034019232*VGS_n + -0.2999469638*VDS_n + 0.0000000000*VBS_n / `sqrt(1.0 + (0.0806543827 + 0.7034019232*VGS_n + -0.2999469638*VDS_n + 0.0000000000*VBS_n)*(0.0806543827 + 0.7034019232*VGS_n + -0.2999469638*VDS_n + 0.0000000000*VBS_n)));
        h1_15 = (0.5676909089 + -0.0240699332*VGS_n + -0.0555549636*VDS_n + -0.0000000000*VBS_n / `sqrt(1.0 + (0.5676909089 + -0.0240699332*VGS_n + -0.0555549636*VDS_n + -0.0000000000*VBS_n)*(0.5676909089 + -0.0240699332*VGS_n + -0.0555549636*VDS_n + -0.0000000000*VBS_n)));
        h1_16 = (-0.2629753053 + -0.0963693559*VGS_n + -0.5784664750*VDS_n + -0.0000000000*VBS_n / `sqrt(1.0 + (-0.2629753053 + -0.0963693559*VGS_n + -0.5784664750*VDS_n + -0.0000000000*VBS_n)*(-0.2629753053 + -0.0963693559*VGS_n + -0.5784664750*VDS_n + -0.0000000000*VBS_n)));
        h1_17 = (0.5256604552 + -0.0437676832*VGS_n + -0.0631933212*VDS_n + 0.0000000000*VBS_n / `sqrt(1.0 + (0.5256604552 + -0.0437676832*VGS_n + -0.0631933212*VDS_n + 0.0000000000*VBS_n)*(0.5256604552 + -0.0437676832*VGS_n + -0.0631933212*VDS_n + 0.0000000000*VBS_n)));
        h1_18 = (-0.6862387061 + 0.0340408459*VGS_n + 0.0272209235*VDS_n + -0.0000000000*VBS_n / `sqrt(1.0 + (-0.6862387061 + 0.0340408459*VGS_n + 0.0272209235*VDS_n + -0.0000000000*VBS_n)*(-0.6862387061 + 0.0340408459*VGS_n + 0.0272209235*VDS_n + -0.0000000000*VBS_n)));
        h1_19 = (-0.4598405063 + 0.0624418184*VGS_n + 0.0647202209*VDS_n + -0.0000000000*VBS_n / `sqrt(1.0 + (-0.4598405063 + 0.0624418184*VGS_n + 0.0647202209*VDS_n + -0.0000000000*VBS_n)*(-0.4598405063 + 0.0624418184*VGS_n + 0.0647202209*VDS_n + -0.0000000000*VBS_n)));
        h1_20 = (0.2712853849 + 0.1136346087*VGS_n + -0.2502560616*VDS_n + 0.0000000000*VBS_n / `sqrt(1.0 + (0.2712853849 + 0.1136346087*VGS_n + -0.2502560616*VDS_n + 0.0000000000*VBS_n)*(0.2712853849 + 0.1136346087*VGS_n + -0.2502560616*VDS_n + 0.0000000000*VBS_n)));
        h1_21 = (0.6220118999 + -0.0142926285*VGS_n + 0.0213798266*VDS_n + 0.0000000000*VBS_n / `sqrt(1.0 + (0.6220118999 + -0.0142926285*VGS_n + 0.0213798266*VDS_n + 0.0000000000*VBS_n)*(0.6220118999 + -0.0142926285*VGS_n + 0.0213798266*VDS_n + 0.0000000000*VBS_n)));
        h1_22 = (0.4362930655 + -0.0426333845*VGS_n + -0.0188672338*VDS_n + 0.0000000000*VBS_n / `sqrt(1.0 + (0.4362930655 + -0.0426333845*VGS_n + -0.0188672338*VDS_n + 0.0000000000*VBS_n)*(0.4362930655 + -0.0426333845*VGS_n + -0.0188672338*VDS_n + 0.0000000000*VBS_n)));
        h1_23 = (0.2830217183 + -0.0260094162*VGS_n + -0.0067754602*VDS_n + -0.0000000000*VBS_n / `sqrt(1.0 + (0.2830217183 + -0.0260094162*VGS_n + -0.0067754602*VDS_n + -0.0000000000*VBS_n)*(0.2830217183 + -0.0260094162*VGS_n + -0.0067754602*VDS_n + -0.0000000000*VBS_n)));
        h1_24 = (-0.7705249786 + 0.0506941676*VGS_n + 0.0018257600*VDS_n + 0.0000000000*VBS_n / `sqrt(1.0 + (-0.7705249786 + 0.0506941676*VGS_n + 0.0018257600*VDS_n + 0.0000000000*VBS_n)*(-0.7705249786 + 0.0506941676*VGS_n + 0.0018257600*VDS_n + 0.0000000000*VBS_n)));
        h1_25 = (0.3717543483 + 0.1964665800*VGS_n + -0.3344590664*VDS_n + -0.0000000000*VBS_n / `sqrt(1.0 + (0.3717543483 + 0.1964665800*VGS_n + -0.3344590664*VDS_n + -0.0000000000*VBS_n)*(0.3717543483 + 0.1964665800*VGS_n + -0.3344590664*VDS_n + -0.0000000000*VBS_n)));
        h1_26 = (-0.9299926162 + -0.5885575414*VGS_n + -0.1342213452*VDS_n + -0.0000000000*VBS_n / `sqrt(1.0 + (-0.9299926162 + -0.5885575414*VGS_n + -0.1342213452*VDS_n + -0.0000000000*VBS_n)*(-0.9299926162 + -0.5885575414*VGS_n + -0.1342213452*VDS_n + -0.0000000000*VBS_n)));
        h1_27 = (-0.6410691738 + 0.0534145050*VGS_n + 0.0103670154*VDS_n + 0.0000000000*VBS_n / `sqrt(1.0 + (-0.6410691738 + 0.0534145050*VGS_n + 0.0103670154*VDS_n + 0.0000000000*VBS_n)*(-0.6410691738 + 0.0534145050*VGS_n + 0.0103670154*VDS_n + 0.0000000000*VBS_n)));
        h1_28 = (-0.0529469103 + -0.3254708052*VGS_n + -0.0931358561*VDS_n + -0.0000000000*VBS_n / `sqrt(1.0 + (-0.0529469103 + -0.3254708052*VGS_n + -0.0931358561*VDS_n + -0.0000000000*VBS_n)*(-0.0529469103 + -0.3254708052*VGS_n + -0.0931358561*VDS_n + -0.0000000000*VBS_n)));
        h1_29 = (-0.5550503731 + 0.0310482141*VGS_n + 0.0027576215*VDS_n + 0.0000000000*VBS_n / `sqrt(1.0 + (-0.5550503731 + 0.0310482141*VGS_n + 0.0027576215*VDS_n + 0.0000000000*VBS_n)*(-0.5550503731 + 0.0310482141*VGS_n + 0.0027576215*VDS_n + 0.0000000000*VBS_n)));
        h1_30 = (0.7034109235 + -0.0860795900*VGS_n + -0.0936738923*VDS_n + -0.0000000000*VBS_n / `sqrt(1.0 + (0.7034109235 + -0.0860795900*VGS_n + -0.0936738923*VDS_n + -0.0000000000*VBS_n)*(0.7034109235 + -0.0860795900*VGS_n + -0.0936738923*VDS_n + -0.0000000000*VBS_n)));
        h1_31 = (-0.3622477651 + 0.8968148232*VGS_n + -0.0100072706*VDS_n + -0.0000000000*VBS_n / `sqrt(1.0 + (-0.3622477651 + 0.8968148232*VGS_n + -0.0100072706*VDS_n + -0.0000000000*VBS_n)*(-0.3622477651 + 0.8968148232*VGS_n + -0.0100072706*VDS_n + -0.0000000000*VBS_n)));

    // Step 3: Hidden Layer 2 (ISRU activation inline)
        h2_0 = (-0.1354256421 + 0.0067107691*h1_0 + 0.0609440282*h1_1 + -0.0008142781*h1_2 + -0.0249209665*h1_3 + 0.1569809467*h1_4 + -0.0077418191*h1_5 + 0.0362650976*h1_6 + 0.0326114632*h1_7 + 0.0984359905*h1_8 + 0.2062325925*h1_9 + 0.2359406948*h1_10 + -0.0017094744*h1_11 + 0.1650174409*h1_12 + -0.1096021309*h1_13 + -0.1544122994*h1_14 + 0.0202184245*h1_15 + 0.2083462328*h1_16 + -0.2284592241*h1_17 + 0.1755926609*h1_18 + -0.0341712572*h1_19 + -0.0047799214*h1_20 + -0.0069724065*h1_21 + -0.1809382588*h1_22 + -0.2251979709*h1_23 + 0.0865808427*h1_24 + 0.0930068418*h1_25 + -0.4193898737*h1_26 + -0.0306183659*h1_27 + -0.1684646606*h1_28 + 0.1563970596*h1_29 + -0.1643774807*h1_30 + -0.2092885673*h1_31 / `sqrt(1.0 + (-0.1354256421 + 0.0067107691*h1_0 + 0.0609440282*h1_1 + -0.0008142781*h1_2 + -0.0249209665*h1_3 + 0.1569809467*h1_4 + -0.0077418191*h1_5 + 0.0362650976*h1_6 + 0.0326114632*h1_7 + 0.0984359905*h1_8 + 0.2062325925*h1_9 + 0.2359406948*h1_10 + -0.0017094744*h1_11 + 0.1650174409*h1_12 + -0.1096021309*h1_13 + -0.1544122994*h1_14 + 0.0202184245*h1_15 + 0.2083462328*h1_16 + -0.2284592241*h1_17 + 0.1755926609*h1_18 + -0.0341712572*h1_19 + -0.0047799214*h1_20 + -0.0069724065*h1_21 + -0.1809382588*h1_22 + -0.2251979709*h1_23 + 0.0865808427*h1_24 + 0.0930068418*h1_25 + -0.4193898737*h1_26 + -0.0306183659*h1_27 + -0.1684646606*h1_28 + 0.1563970596*h1_29 + -0.1643774807*h1_30 + -0.2092885673*h1_31)*(-0.1354256421 + 0.0067107691*h1_0 + 0.0609440282*h1_1 + -0.0008142781*h1_2 + -0.0249209665*h1_3 + 0.1569809467*h1_4 + -0.0077418191*h1_5 + 0.0362650976*h1_6 + 0.0326114632*h1_7 + 0.0984359905*h1_8 + 0.2062325925*h1_9 + 0.2359406948*h1_10 + -0.0017094744*h1_11 + 0.1650174409*h1_12 + -0.1096021309*h1_13 + -0.1544122994*h1_14 + 0.0202184245*h1_15 + 0.2083462328*h1_16 + -0.2284592241*h1_17 + 0.1755926609*h1_18 + -0.0341712572*h1_19 + -0.0047799214*h1_20 + -0.0069724065*h1_21 + -0.1809382588*h1_22 + -0.2251979709*h1_23 + 0.0865808427*h1_24 + 0.0930068418*h1_25 + -0.4193898737*h1_26 + -0.0306183659*h1_27 + -0.1684646606*h1_28 + 0.1563970596*h1_29 + -0.1643774807*h1_30 + -0.2092885673*h1_31)));
        h2_1 = (0.2268761843 + 0.0455713756*h1_0 + -0.0636425912*h1_1 + -0.1773278266*h1_2 + 0.0109009612*h1_3 + -0.3900153339*h1_4 + 0.0348566845*h1_5 + -0.1088789925*h1_6 + -0.0823950320*h1_7 + 0.0188722927*h1_8 + -0.0317084156*h1_9 + -0.2512015104*h1_10 + 0.0304715764*h1_11 + 0.0918777213*h1_12 + -0.1988182217*h1_13 + -0.0002208436*h1_14 + 0.0154112494*h1_15 + -0.0195617788*h1_16 + 0.1448661685*h1_17 + -0.2911064625*h1_18 + -0.0119480509*h1_19 + -0.0942192227*h1_20 + 0.2980673909*h1_21 + 0.0296341758*h1_22 + 0.1109367311*h1_23 + -0.0510958619*h1_24 + -0.0721297488*h1_25 + 0.4788790047*h1_26 + -0.2209216207*h1_27 + 0.0514231622*h1_28 + -0.2528284788*h1_29 + 0.1192876026*h1_30 + 0.3947262764*h1_31 / `sqrt(1.0 + (0.2268761843 + 0.0455713756*h1_0 + -0.0636425912*h1_1 + -0.1773278266*h1_2 + 0.0109009612*h1_3 + -0.3900153339*h1_4 + 0.0348566845*h1_5 + -0.1088789925*h1_6 + -0.0823950320*h1_7 + 0.0188722927*h1_8 + -0.0317084156*h1_9 + -0.2512015104*h1_10 + 0.0304715764*h1_11 + 0.0918777213*h1_12 + -0.1988182217*h1_13 + -0.0002208436*h1_14 + 0.0154112494*h1_15 + -0.0195617788*h1_16 + 0.1448661685*h1_17 + -0.2911064625*h1_18 + -0.0119480509*h1_19 + -0.0942192227*h1_20 + 0.2980673909*h1_21 + 0.0296341758*h1_22 + 0.1109367311*h1_23 + -0.0510958619*h1_24 + -0.0721297488*h1_25 + 0.4788790047*h1_26 + -0.2209216207*h1_27 + 0.0514231622*h1_28 + -0.2528284788*h1_29 + 0.1192876026*h1_30 + 0.3947262764*h1_31)*(0.2268761843 + 0.0455713756*h1_0 + -0.0636425912*h1_1 + -0.1773278266*h1_2 + 0.0109009612*h1_3 + -0.3900153339*h1_4 + 0.0348566845*h1_5 + -0.1088789925*h1_6 + -0.0823950320*h1_7 + 0.0188722927*h1_8 + -0.0317084156*h1_9 + -0.2512015104*h1_10 + 0.0304715764*h1_11 + 0.0918777213*h1_12 + -0.1988182217*h1_13 + -0.0002208436*h1_14 + 0.0154112494*h1_15 + -0.0195617788*h1_16 + 0.1448661685*h1_17 + -0.2911064625*h1_18 + -0.0119480509*h1_19 + -0.0942192227*h1_20 + 0.2980673909*h1_21 + 0.0296341758*h1_22 + 0.1109367311*h1_23 + -0.0510958619*h1_24 + -0.0721297488*h1_25 + 0.4788790047*h1_26 + -0.2209216207*h1_27 + 0.0514231622*h1_28 + -0.2528284788*h1_29 + 0.1192876026*h1_30 + 0.3947262764*h1_31)));
        h2_2 = (-0.2264913768 + -0.1074565351*h1_0 + -0.0895827785*h1_1 + -0.1235724837*h1_2 + -0.0071372921*h1_3 + 0.2366294861*h1_4 + 0.2553648353*h1_5 + 0.3364000022*h1_6 + -0.0313286930*h1_7 + -0.0644339621*h1_8 + 0.2864151597*h1_9 + 0.1730063856*h1_10 + -0.2081170827*h1_11 + -0.1046097800*h1_12 + 0.1138121635*h1_13 + 0.1246100515*h1_14 + -0.1014657244*h1_15 + -0.3946498334*h1_16 + -0.1535910815*h1_17 + 0.0734622553*h1_18 + 0.1895205230*h1_19 + -0.2416153997*h1_20 + -0.1606592536*h1_21 + -0.0051006586*h1_22 + -0.0303584281*h1_23 + 0.1989510208*h1_24 + 0.3099069595*h1_25 + -0.1532381922*h1_26 + 0.1899495423*h1_27 + -0.1341999322*h1_28 + 0.1841496676*h1_29 + 0.0376099236*h1_30 + 0.1071342602*h1_31 / `sqrt(1.0 + (-0.2264913768 + -0.1074565351*h1_0 + -0.0895827785*h1_1 + -0.1235724837*h1_2 + -0.0071372921*h1_3 + 0.2366294861*h1_4 + 0.2553648353*h1_5 + 0.3364000022*h1_6 + -0.0313286930*h1_7 + -0.0644339621*h1_8 + 0.2864151597*h1_9 + 0.1730063856*h1_10 + -0.2081170827*h1_11 + -0.1046097800*h1_12 + 0.1138121635*h1_13 + 0.1246100515*h1_14 + -0.1014657244*h1_15 + -0.3946498334*h1_16 + -0.1535910815*h1_17 + 0.0734622553*h1_18 + 0.1895205230*h1_19 + -0.2416153997*h1_20 + -0.1606592536*h1_21 + -0.0051006586*h1_22 + -0.0303584281*h1_23 + 0.1989510208*h1_24 + 0.3099069595*h1_25 + -0.1532381922*h1_26 + 0.1899495423*h1_27 + -0.1341999322*h1_28 + 0.1841496676*h1_29 + 0.0376099236*h1_30 + 0.1071342602*h1_31)*(-0.2264913768 + -0.1074565351*h1_0 + -0.0895827785*h1_1 + -0.1235724837*h1_2 + -0.0071372921*h1_3 + 0.2366294861*h1_4 + 0.2553648353*h1_5 + 0.3364000022*h1_6 + -0.0313286930*h1_7 + -0.0644339621*h1_8 + 0.2864151597*h1_9 + 0.1730063856*h1_10 + -0.2081170827*h1_11 + -0.1046097800*h1_12 + 0.1138121635*h1_13 + 0.1246100515*h1_14 + -0.1014657244*h1_15 + -0.3946498334*h1_16 + -0.1535910815*h1_17 + 0.0734622553*h1_18 + 0.1895205230*h1_19 + -0.2416153997*h1_20 + -0.1606592536*h1_21 + -0.0051006586*h1_22 + -0.0303584281*h1_23 + 0.1989510208*h1_24 + 0.3099069595*h1_25 + -0.1532381922*h1_26 + 0.1899495423*h1_27 + -0.1341999322*h1_28 + 0.1841496676*h1_29 + 0.0376099236*h1_30 + 0.1071342602*h1_31)));
        h2_3 = (0.0243124217 + 0.0296399035*h1_0 + -0.1285935193*h1_1 + 0.0250538699*h1_2 + -0.0566796623*h1_3 + 0.0337372534*h1_4 + 0.0028880022*h1_5 + -0.0270623229*h1_6 + 0.1099896207*h1_7 + 0.1583129764*h1_8 + -0.0077291103*h1_9 + 0.2252104282*h1_10 + -0.0650983527*h1_11 + -0.2467005998*h1_12 + 0.1989165395*h1_13 + 0.1162165999*h1_14 + 0.0321946666*h1_15 + -0.0516977981*h1_16 + 0.0213029757*h1_17 + 0.0149309961*h1_18 + 0.0512646697*h1_19 + -0.0798383206*h1_20 + 0.0363552198*h1_21 + -0.0507423989*h1_22 + -0.2899200916*h1_23 + 0.2763773501*h1_24 + -0.0320890620*h1_25 + -0.0611791871*h1_26 + 0.2798025310*h1_27 + -0.0043937559*h1_28 + 0.3075855672*h1_29 + -0.0057631680*h1_30 + -0.0089399656*h1_31 / `sqrt(1.0 + (0.0243124217 + 0.0296399035*h1_0 + -0.1285935193*h1_1 + 0.0250538699*h1_2 + -0.0566796623*h1_3 + 0.0337372534*h1_4 + 0.0028880022*h1_5 + -0.0270623229*h1_6 + 0.1099896207*h1_7 + 0.1583129764*h1_8 + -0.0077291103*h1_9 + 0.2252104282*h1_10 + -0.0650983527*h1_11 + -0.2467005998*h1_12 + 0.1989165395*h1_13 + 0.1162165999*h1_14 + 0.0321946666*h1_15 + -0.0516977981*h1_16 + 0.0213029757*h1_17 + 0.0149309961*h1_18 + 0.0512646697*h1_19 + -0.0798383206*h1_20 + 0.0363552198*h1_21 + -0.0507423989*h1_22 + -0.2899200916*h1_23 + 0.2763773501*h1_24 + -0.0320890620*h1_25 + -0.0611791871*h1_26 + 0.2798025310*h1_27 + -0.0043937559*h1_28 + 0.3075855672*h1_29 + -0.0057631680*h1_30 + -0.0089399656*h1_31)*(0.0243124217 + 0.0296399035*h1_0 + -0.1285935193*h1_1 + 0.0250538699*h1_2 + -0.0566796623*h1_3 + 0.0337372534*h1_4 + 0.0028880022*h1_5 + -0.0270623229*h1_6 + 0.1099896207*h1_7 + 0.1583129764*h1_8 + -0.0077291103*h1_9 + 0.2252104282*h1_10 + -0.0650983527*h1_11 + -0.2467005998*h1_12 + 0.1989165395*h1_13 + 0.1162165999*h1_14 + 0.0321946666*h1_15 + -0.0516977981*h1_16 + 0.0213029757*h1_17 + 0.0149309961*h1_18 + 0.0512646697*h1_19 + -0.0798383206*h1_20 + 0.0363552198*h1_21 + -0.0507423989*h1_22 + -0.2899200916*h1_23 + 0.2763773501*h1_24 + -0.0320890620*h1_25 + -0.0611791871*h1_26 + 0.2798025310*h1_27 + -0.0043937559*h1_28 + 0.3075855672*h1_29 + -0.0057631680*h1_30 + -0.0089399656*h1_31)));
        h2_4 = (-0.1309534907 + -0.0581011809*h1_0 + 0.0948147848*h1_1 + 0.0742766708*h1_2 + -0.0231378786*h1_3 + 0.1585719734*h1_4 + -0.0306360219*h1_5 + 0.0172835961*h1_6 + 0.0441506915*h1_7 + 0.3527320921*h1_8 + -0.0462188236*h1_9 + 0.1157925650*h1_10 + -0.1760286987*h1_11 + 0.0882858261*h1_12 + -0.1188422367*h1_13 + -0.1614190787*h1_14 + -0.1927610636*h1_15 + 0.1832501739*h1_16 + -0.2722839415*h1_17 + 0.0579173751*h1_18 + 0.1171146259*h1_19 + 0.0830877349*h1_20 + -0.1965682656*h1_21 + -0.0870302543*h1_22 + -0.2701533139*h1_23 + -0.0553756505*h1_24 + 0.0634624809*h1_25 + -0.4088450968*h1_26 + 0.2200900018*h1_27 + -0.1486335993*h1_28 + 0.1144801602*h1_29 + -0.0037541345*h1_30 + -0.2371181101*h1_31 / `sqrt(1.0 + (-0.1309534907 + -0.0581011809*h1_0 + 0.0948147848*h1_1 + 0.0742766708*h1_2 + -0.0231378786*h1_3 + 0.1585719734*h1_4 + -0.0306360219*h1_5 + 0.0172835961*h1_6 + 0.0441506915*h1_7 + 0.3527320921*h1_8 + -0.0462188236*h1_9 + 0.1157925650*h1_10 + -0.1760286987*h1_11 + 0.0882858261*h1_12 + -0.1188422367*h1_13 + -0.1614190787*h1_14 + -0.1927610636*h1_15 + 0.1832501739*h1_16 + -0.2722839415*h1_17 + 0.0579173751*h1_18 + 0.1171146259*h1_19 + 0.0830877349*h1_20 + -0.1965682656*h1_21 + -0.0870302543*h1_22 + -0.2701533139*h1_23 + -0.0553756505*h1_24 + 0.0634624809*h1_25 + -0.4088450968*h1_26 + 0.2200900018*h1_27 + -0.1486335993*h1_28 + 0.1144801602*h1_29 + -0.0037541345*h1_30 + -0.2371181101*h1_31)*(-0.1309534907 + -0.0581011809*h1_0 + 0.0948147848*h1_1 + 0.0742766708*h1_2 + -0.0231378786*h1_3 + 0.1585719734*h1_4 + -0.0306360219*h1_5 + 0.0172835961*h1_6 + 0.0441506915*h1_7 + 0.3527320921*h1_8 + -0.0462188236*h1_9 + 0.1157925650*h1_10 + -0.1760286987*h1_11 + 0.0882858261*h1_12 + -0.1188422367*h1_13 + -0.1614190787*h1_14 + -0.1927610636*h1_15 + 0.1832501739*h1_16 + -0.2722839415*h1_17 + 0.0579173751*h1_18 + 0.1171146259*h1_19 + 0.0830877349*h1_20 + -0.1965682656*h1_21 + -0.0870302543*h1_22 + -0.2701533139*h1_23 + -0.0553756505*h1_24 + 0.0634624809*h1_25 + -0.4088450968*h1_26 + 0.2200900018*h1_27 + -0.1486335993*h1_28 + 0.1144801602*h1_29 + -0.0037541345*h1_30 + -0.2371181101*h1_31)));
        h2_5 = (0.0823178291 + 0.1973859221*h1_0 + -0.0360411294*h1_1 + -0.1790995598*h1_2 + -0.0046332898*h1_3 + -0.3501120508*h1_4 + -0.0662217587*h1_5 + -0.1786303669*h1_6 + 0.0297072381*h1_7 + -0.1881985068*h1_8 + 0.1126292050*h1_9 + -0.1429433674*h1_10 + 0.1983506680*h1_11 + 0.0253197029*h1_12 + 0.0406744778*h1_13 + 0.2271536440*h1_14 + 0.2389491051*h1_15 + -0.1112041920*h1_16 + 0.0964495018*h1_17 + -0.2863586843*h1_18 + -0.0893413201*h1_19 + -0.0166173428*h1_20 + 0.2702391148*h1_21 + 0.1472478807*h1_22 + 0.1301505566*h1_23 + -0.1864297241*h1_24 + -0.1939381659*h1_25 + 0.4549899101*h1_26 + -0.1575466990*h1_27 + 0.0043197502*h1_28 + 0.0290980432*h1_29 + -0.0390490666*h1_30 + 0.1755205840*h1_31 / `sqrt(1.0 + (0.0823178291 + 0.1973859221*h1_0 + -0.0360411294*h1_1 + -0.1790995598*h1_2 + -0.0046332898*h1_3 + -0.3501120508*h1_4 + -0.0662217587*h1_5 + -0.1786303669*h1_6 + 0.0297072381*h1_7 + -0.1881985068*h1_8 + 0.1126292050*h1_9 + -0.1429433674*h1_10 + 0.1983506680*h1_11 + 0.0253197029*h1_12 + 0.0406744778*h1_13 + 0.2271536440*h1_14 + 0.2389491051*h1_15 + -0.1112041920*h1_16 + 0.0964495018*h1_17 + -0.2863586843*h1_18 + -0.0893413201*h1_19 + -0.0166173428*h1_20 + 0.2702391148*h1_21 + 0.1472478807*h1_22 + 0.1301505566*h1_23 + -0.1864297241*h1_24 + -0.1939381659*h1_25 + 0.4549899101*h1_26 + -0.1575466990*h1_27 + 0.0043197502*h1_28 + 0.0290980432*h1_29 + -0.0390490666*h1_30 + 0.1755205840*h1_31)*(0.0823178291 + 0.1973859221*h1_0 + -0.0360411294*h1_1 + -0.1790995598*h1_2 + -0.0046332898*h1_3 + -0.3501120508*h1_4 + -0.0662217587*h1_5 + -0.1786303669*h1_6 + 0.0297072381*h1_7 + -0.1881985068*h1_8 + 0.1126292050*h1_9 + -0.1429433674*h1_10 + 0.1983506680*h1_11 + 0.0253197029*h1_12 + 0.0406744778*h1_13 + 0.2271536440*h1_14 + 0.2389491051*h1_15 + -0.1112041920*h1_16 + 0.0964495018*h1_17 + -0.2863586843*h1_18 + -0.0893413201*h1_19 + -0.0166173428*h1_20 + 0.2702391148*h1_21 + 0.1472478807*h1_22 + 0.1301505566*h1_23 + -0.1864297241*h1_24 + -0.1939381659*h1_25 + 0.4549899101*h1_26 + -0.1575466990*h1_27 + 0.0043197502*h1_28 + 0.0290980432*h1_29 + -0.0390490666*h1_30 + 0.1755205840*h1_31)));
        h2_6 = (-0.0704899356 + 0.1046413258*h1_0 + 0.1103503257*h1_1 + -0.1889455467*h1_2 + 0.1411332488*h1_3 + -0.1215768158*h1_4 + -0.0177851748*h1_5 + 0.1075054482*h1_6 + -0.0590939969*h1_7 + -0.1912639737*h1_8 + 0.1382379383*h1_9 + -0.3515523672*h1_10 + 0.1267971396*h1_11 + -0.1516908109*h1_12 + -0.1499213874*h1_13 + 0.2325850725*h1_14 + -0.0025136133*h1_15 + -0.0658451170*h1_16 + 0.2098426372*h1_17 + -0.2516526580*h1_18 + -0.2337839156*h1_19 + 0.0321675390*h1_20 + 0.2547390163*h1_21 + 0.0929529369*h1_22 + 0.2434149534*h1_23 + 0.0054784934*h1_24 + -0.0127595002*h1_25 + 0.2209061980*h1_26 + 0.0998968035*h1_27 + 0.1139809862*h1_28 + -0.0590747297*h1_29 + 0.1721152961*h1_30 + 0.0222837478*h1_31 / `sqrt(1.0 + (-0.0704899356 + 0.1046413258*h1_0 + 0.1103503257*h1_1 + -0.1889455467*h1_2 + 0.1411332488*h1_3 + -0.1215768158*h1_4 + -0.0177851748*h1_5 + 0.1075054482*h1_6 + -0.0590939969*h1_7 + -0.1912639737*h1_8 + 0.1382379383*h1_9 + -0.3515523672*h1_10 + 0.1267971396*h1_11 + -0.1516908109*h1_12 + -0.1499213874*h1_13 + 0.2325850725*h1_14 + -0.0025136133*h1_15 + -0.0658451170*h1_16 + 0.2098426372*h1_17 + -0.2516526580*h1_18 + -0.2337839156*h1_19 + 0.0321675390*h1_20 + 0.2547390163*h1_21 + 0.0929529369*h1_22 + 0.2434149534*h1_23 + 0.0054784934*h1_24 + -0.0127595002*h1_25 + 0.2209061980*h1_26 + 0.0998968035*h1_27 + 0.1139809862*h1_28 + -0.0590747297*h1_29 + 0.1721152961*h1_30 + 0.0222837478*h1_31)*(-0.0704899356 + 0.1046413258*h1_0 + 0.1103503257*h1_1 + -0.1889455467*h1_2 + 0.1411332488*h1_3 + -0.1215768158*h1_4 + -0.0177851748*h1_5 + 0.1075054482*h1_6 + -0.0590939969*h1_7 + -0.1912639737*h1_8 + 0.1382379383*h1_9 + -0.3515523672*h1_10 + 0.1267971396*h1_11 + -0.1516908109*h1_12 + -0.1499213874*h1_13 + 0.2325850725*h1_14 + -0.0025136133*h1_15 + -0.0658451170*h1_16 + 0.2098426372*h1_17 + -0.2516526580*h1_18 + -0.2337839156*h1_19 + 0.0321675390*h1_20 + 0.2547390163*h1_21 + 0.0929529369*h1_22 + 0.2434149534*h1_23 + 0.0054784934*h1_24 + -0.0127595002*h1_25 + 0.2209061980*h1_26 + 0.0998968035*h1_27 + 0.1139809862*h1_28 + -0.0590747297*h1_29 + 0.1721152961*h1_30 + 0.0222837478*h1_31)));
        h2_7 = (0.3887178898 + 0.3885630667*h1_0 + 0.1124729440*h1_1 + 0.2443935424*h1_2 + 0.2867910862*h1_3 + -0.0112769622*h1_4 + -0.2509107292*h1_5 + -0.1293168068*h1_6 + 0.2279208601*h1_7 + 0.2672553360*h1_8 + -0.2273536921*h1_9 + 0.1461210698*h1_10 + 0.1950331777*h1_11 + 0.0302690286*h1_12 + -0.1021309644*h1_13 + 0.0140834544*h1_14 + 0.3671791255*h1_15 + -0.1656612158*h1_16 + 0.4069385529*h1_17 + -0.3501166105*h1_18 + -0.1792891771*h1_19 + -0.0115753980*h1_20 + 0.4163833857*h1_21 + 0.3161748350*h1_22 + 0.1837892532*h1_23 + -0.1787855476*h1_24 + 0.2869756222*h1_25 + -0.1892038286*h1_26 + -0.2433715761*h1_27 + 0.0294444934*h1_28 + -0.2753538191*h1_29 + 0.1159083396*h1_30 + -0.3370322585*h1_31 / `sqrt(1.0 + (0.3887178898 + 0.3885630667*h1_0 + 0.1124729440*h1_1 + 0.2443935424*h1_2 + 0.2867910862*h1_3 + -0.0112769622*h1_4 + -0.2509107292*h1_5 + -0.1293168068*h1_6 + 0.2279208601*h1_7 + 0.2672553360*h1_8 + -0.2273536921*h1_9 + 0.1461210698*h1_10 + 0.1950331777*h1_11 + 0.0302690286*h1_12 + -0.1021309644*h1_13 + 0.0140834544*h1_14 + 0.3671791255*h1_15 + -0.1656612158*h1_16 + 0.4069385529*h1_17 + -0.3501166105*h1_18 + -0.1792891771*h1_19 + -0.0115753980*h1_20 + 0.4163833857*h1_21 + 0.3161748350*h1_22 + 0.1837892532*h1_23 + -0.1787855476*h1_24 + 0.2869756222*h1_25 + -0.1892038286*h1_26 + -0.2433715761*h1_27 + 0.0294444934*h1_28 + -0.2753538191*h1_29 + 0.1159083396*h1_30 + -0.3370322585*h1_31)*(0.3887178898 + 0.3885630667*h1_0 + 0.1124729440*h1_1 + 0.2443935424*h1_2 + 0.2867910862*h1_3 + -0.0112769622*h1_4 + -0.2509107292*h1_5 + -0.1293168068*h1_6 + 0.2279208601*h1_7 + 0.2672553360*h1_8 + -0.2273536921*h1_9 + 0.1461210698*h1_10 + 0.1950331777*h1_11 + 0.0302690286*h1_12 + -0.1021309644*h1_13 + 0.0140834544*h1_14 + 0.3671791255*h1_15 + -0.1656612158*h1_16 + 0.4069385529*h1_17 + -0.3501166105*h1_18 + -0.1792891771*h1_19 + -0.0115753980*h1_20 + 0.4163833857*h1_21 + 0.3161748350*h1_22 + 0.1837892532*h1_23 + -0.1787855476*h1_24 + 0.2869756222*h1_25 + -0.1892038286*h1_26 + -0.2433715761*h1_27 + 0.0294444934*h1_28 + -0.2753538191*h1_29 + 0.1159083396*h1_30 + -0.3370322585*h1_31)));
        h2_8 = (-0.1364357471 + -0.1755099148*h1_0 + -0.1747999489*h1_1 + 0.2283590436*h1_2 + -0.0834070519*h1_3 + 0.1978651881*h1_4 + -0.1021732464*h1_5 + 0.0527679808*h1_6 + -0.0311461259*h1_7 + 0.1828521043*h1_8 + 0.0027645170*h1_9 + 0.2754266858*h1_10 + -0.0567712113*h1_11 + 0.0203668773*h1_12 + 0.2003012598*h1_13 + 0.0878850967*h1_14 + 0.0350542516*h1_15 + -0.0415128469*h1_16 + -0.2118604779*h1_17 + 0.1349029839*h1_18 + -0.0026048857*h1_19 + -0.0001540357*h1_20 + -0.1474816799*h1_21 + -0.1960860342*h1_22 + -0.3002485335*h1_23 + 0.1648500860*h1_24 + 0.1542220563*h1_25 + -0.3070231080*h1_26 + 0.0299708936*h1_27 + -0.0682941750*h1_28 + 0.1218002215*h1_29 + -0.1845901608*h1_30 + -0.2592646480*h1_31 / `sqrt(1.0 + (-0.1364357471 + -0.1755099148*h1_0 + -0.1747999489*h1_1 + 0.2283590436*h1_2 + -0.0834070519*h1_3 + 0.1978651881*h1_4 + -0.1021732464*h1_5 + 0.0527679808*h1_6 + -0.0311461259*h1_7 + 0.1828521043*h1_8 + 0.0027645170*h1_9 + 0.2754266858*h1_10 + -0.0567712113*h1_11 + 0.0203668773*h1_12 + 0.2003012598*h1_13 + 0.0878850967*h1_14 + 0.0350542516*h1_15 + -0.0415128469*h1_16 + -0.2118604779*h1_17 + 0.1349029839*h1_18 + -0.0026048857*h1_19 + -0.0001540357*h1_20 + -0.1474816799*h1_21 + -0.1960860342*h1_22 + -0.3002485335*h1_23 + 0.1648500860*h1_24 + 0.1542220563*h1_25 + -0.3070231080*h1_26 + 0.0299708936*h1_27 + -0.0682941750*h1_28 + 0.1218002215*h1_29 + -0.1845901608*h1_30 + -0.2592646480*h1_31)*(-0.1364357471 + -0.1755099148*h1_0 + -0.1747999489*h1_1 + 0.2283590436*h1_2 + -0.0834070519*h1_3 + 0.1978651881*h1_4 + -0.1021732464*h1_5 + 0.0527679808*h1_6 + -0.0311461259*h1_7 + 0.1828521043*h1_8 + 0.0027645170*h1_9 + 0.2754266858*h1_10 + -0.0567712113*h1_11 + 0.0203668773*h1_12 + 0.2003012598*h1_13 + 0.0878850967*h1_14 + 0.0350542516*h1_15 + -0.0415128469*h1_16 + -0.2118604779*h1_17 + 0.1349029839*h1_18 + -0.0026048857*h1_19 + -0.0001540357*h1_20 + -0.1474816799*h1_21 + -0.1960860342*h1_22 + -0.3002485335*h1_23 + 0.1648500860*h1_24 + 0.1542220563*h1_25 + -0.3070231080*h1_26 + 0.0299708936*h1_27 + -0.0682941750*h1_28 + 0.1218002215*h1_29 + -0.1845901608*h1_30 + -0.2592646480*h1_31)));
        h2_9 = (0.2238848507 + 0.0201064590*h1_0 + -0.0595537834*h1_1 + 0.0561622716*h1_2 + 0.1540087610*h1_3 + -0.0903293937*h1_4 + 0.3122811317*h1_5 + 0.2120015770*h1_6 + -0.0312335845*h1_7 + -0.1090965271*h1_8 + -0.0750334635*h1_9 + -0.3330971897*h1_10 + -0.0074974173*h1_11 + -0.0084595783*h1_12 + 0.1555107534*h1_13 + 0.2765473127*h1_14 + 0.0272881538*h1_15 + -0.1218964979*h1_16 + -0.0244188923*h1_17 + 0.0022994000*h1_18 + -0.2070706934*h1_19 + -0.1078958884*h1_20 + 0.2286056429*h1_21 + 0.1547257006*h1_22 + 0.0355852656*h1_23 + -0.1775801182*h1_24 + -0.1529259682*h1_25 + 0.4586740434*h1_26 + -0.2329952121*h1_27 + 0.1554664075*h1_28 + 0.0524597690*h1_29 + 0.0617493875*h1_30 + 0.1259837896*h1_31 / `sqrt(1.0 + (0.2238848507 + 0.0201064590*h1_0 + -0.0595537834*h1_1 + 0.0561622716*h1_2 + 0.1540087610*h1_3 + -0.0903293937*h1_4 + 0.3122811317*h1_5 + 0.2120015770*h1_6 + -0.0312335845*h1_7 + -0.1090965271*h1_8 + -0.0750334635*h1_9 + -0.3330971897*h1_10 + -0.0074974173*h1_11 + -0.0084595783*h1_12 + 0.1555107534*h1_13 + 0.2765473127*h1_14 + 0.0272881538*h1_15 + -0.1218964979*h1_16 + -0.0244188923*h1_17 + 0.0022994000*h1_18 + -0.2070706934*h1_19 + -0.1078958884*h1_20 + 0.2286056429*h1_21 + 0.1547257006*h1_22 + 0.0355852656*h1_23 + -0.1775801182*h1_24 + -0.1529259682*h1_25 + 0.4586740434*h1_26 + -0.2329952121*h1_27 + 0.1554664075*h1_28 + 0.0524597690*h1_29 + 0.0617493875*h1_30 + 0.1259837896*h1_31)*(0.2238848507 + 0.0201064590*h1_0 + -0.0595537834*h1_1 + 0.0561622716*h1_2 + 0.1540087610*h1_3 + -0.0903293937*h1_4 + 0.3122811317*h1_5 + 0.2120015770*h1_6 + -0.0312335845*h1_7 + -0.1090965271*h1_8 + -0.0750334635*h1_9 + -0.3330971897*h1_10 + -0.0074974173*h1_11 + -0.0084595783*h1_12 + 0.1555107534*h1_13 + 0.2765473127*h1_14 + 0.0272881538*h1_15 + -0.1218964979*h1_16 + -0.0244188923*h1_17 + 0.0022994000*h1_18 + -0.2070706934*h1_19 + -0.1078958884*h1_20 + 0.2286056429*h1_21 + 0.1547257006*h1_22 + 0.0355852656*h1_23 + -0.1775801182*h1_24 + -0.1529259682*h1_25 + 0.4586740434*h1_26 + -0.2329952121*h1_27 + 0.1554664075*h1_28 + 0.0524597690*h1_29 + 0.0617493875*h1_30 + 0.1259837896*h1_31)));
        h2_10 = (-0.0253829788 + 0.0676963404*h1_0 + 0.1134642437*h1_1 + 0.0415690541*h1_2 + 0.2313092500*h1_3 + -0.2294330746*h1_4 + 0.2701669931*h1_5 + 0.2228933424*h1_6 + -0.1524830461*h1_7 + -0.0831195116*h1_8 + -0.1088727489*h1_9 + -0.3253349960*h1_10 + 0.0227852575*h1_11 + -0.1356610507*h1_12 + 0.0141303372*h1_13 + 0.0714161918*h1_14 + 0.1831130832*h1_15 + 0.0725831017*h1_16 + 0.0732851475*h1_17 + -0.2250668705*h1_18 + -0.0928964317*h1_19 + -0.1764908582*h1_20 + -0.0472666360*h1_21 + 0.0542525798*h1_22 + 0.2271831781*h1_23 + -0.1906152368*h1_24 + -0.0094799781*h1_25 + 0.2233636826*h1_26 + -0.2310741246*h1_27 + -0.0497361682*h1_28 + -0.0985101238*h1_29 + 0.0140689546*h1_30 + 0.3274868727*h1_31 / `sqrt(1.0 + (-0.0253829788 + 0.0676963404*h1_0 + 0.1134642437*h1_1 + 0.0415690541*h1_2 + 0.2313092500*h1_3 + -0.2294330746*h1_4 + 0.2701669931*h1_5 + 0.2228933424*h1_6 + -0.1524830461*h1_7 + -0.0831195116*h1_8 + -0.1088727489*h1_9 + -0.3253349960*h1_10 + 0.0227852575*h1_11 + -0.1356610507*h1_12 + 0.0141303372*h1_13 + 0.0714161918*h1_14 + 0.1831130832*h1_15 + 0.0725831017*h1_16 + 0.0732851475*h1_17 + -0.2250668705*h1_18 + -0.0928964317*h1_19 + -0.1764908582*h1_20 + -0.0472666360*h1_21 + 0.0542525798*h1_22 + 0.2271831781*h1_23 + -0.1906152368*h1_24 + -0.0094799781*h1_25 + 0.2233636826*h1_26 + -0.2310741246*h1_27 + -0.0497361682*h1_28 + -0.0985101238*h1_29 + 0.0140689546*h1_30 + 0.3274868727*h1_31)*(-0.0253829788 + 0.0676963404*h1_0 + 0.1134642437*h1_1 + 0.0415690541*h1_2 + 0.2313092500*h1_3 + -0.2294330746*h1_4 + 0.2701669931*h1_5 + 0.2228933424*h1_6 + -0.1524830461*h1_7 + -0.0831195116*h1_8 + -0.1088727489*h1_9 + -0.3253349960*h1_10 + 0.0227852575*h1_11 + -0.1356610507*h1_12 + 0.0141303372*h1_13 + 0.0714161918*h1_14 + 0.1831130832*h1_15 + 0.0725831017*h1_16 + 0.0732851475*h1_17 + -0.2250668705*h1_18 + -0.0928964317*h1_19 + -0.1764908582*h1_20 + -0.0472666360*h1_21 + 0.0542525798*h1_22 + 0.2271831781*h1_23 + -0.1906152368*h1_24 + -0.0094799781*h1_25 + 0.2233636826*h1_26 + -0.2310741246*h1_27 + -0.0497361682*h1_28 + -0.0985101238*h1_29 + 0.0140689546*h1_30 + 0.3274868727*h1_31)));
        h2_11 = (-0.3037748039 + -0.0663033351*h1_0 + 0.0489777699*h1_1 + 0.1818473339*h1_2 + -0.1372460276*h1_3 + 0.3917323649*h1_4 + -0.1172484457*h1_5 + -0.0185083859*h1_6 + 0.1861010343*h1_7 + 0.1039791703*h1_8 + 0.1144099832*h1_9 + 0.1079650745*h1_10 + -0.1669557542*h1_11 + -0.0070614568*h1_12 + 0.1054669619*h1_13 + -0.0978581309*h1_14 + -0.0918243751*h1_15 + -0.0271060020*h1_16 + -0.2439425141*h1_17 + 0.2928464115*h1_18 + -0.0332152508*h1_19 + 0.0613961816*h1_20 + -0.0180926062*h1_21 + -0.0455776677*h1_22 + -0.1167580336*h1_23 + -0.0540605783*h1_24 + 0.1314576566*h1_25 + -0.4689130187*h1_26 + 0.0751900077*h1_27 + 0.0552215874*h1_28 + 0.0912570581*h1_29 + -0.1978882253*h1_30 + -0.3326123655*h1_31 / `sqrt(1.0 + (-0.3037748039 + -0.0663033351*h1_0 + 0.0489777699*h1_1 + 0.1818473339*h1_2 + -0.1372460276*h1_3 + 0.3917323649*h1_4 + -0.1172484457*h1_5 + -0.0185083859*h1_6 + 0.1861010343*h1_7 + 0.1039791703*h1_8 + 0.1144099832*h1_9 + 0.1079650745*h1_10 + -0.1669557542*h1_11 + -0.0070614568*h1_12 + 0.1054669619*h1_13 + -0.0978581309*h1_14 + -0.0918243751*h1_15 + -0.0271060020*h1_16 + -0.2439425141*h1_17 + 0.2928464115*h1_18 + -0.0332152508*h1_19 + 0.0613961816*h1_20 + -0.0180926062*h1_21 + -0.0455776677*h1_22 + -0.1167580336*h1_23 + -0.0540605783*h1_24 + 0.1314576566*h1_25 + -0.4689130187*h1_26 + 0.0751900077*h1_27 + 0.0552215874*h1_28 + 0.0912570581*h1_29 + -0.1978882253*h1_30 + -0.3326123655*h1_31)*(-0.3037748039 + -0.0663033351*h1_0 + 0.0489777699*h1_1 + 0.1818473339*h1_2 + -0.1372460276*h1_3 + 0.3917323649*h1_4 + -0.1172484457*h1_5 + -0.0185083859*h1_6 + 0.1861010343*h1_7 + 0.1039791703*h1_8 + 0.1144099832*h1_9 + 0.1079650745*h1_10 + -0.1669557542*h1_11 + -0.0070614568*h1_12 + 0.1054669619*h1_13 + -0.0978581309*h1_14 + -0.0918243751*h1_15 + -0.0271060020*h1_16 + -0.2439425141*h1_17 + 0.2928464115*h1_18 + -0.0332152508*h1_19 + 0.0613961816*h1_20 + -0.0180926062*h1_21 + -0.0455776677*h1_22 + -0.1167580336*h1_23 + -0.0540605783*h1_24 + 0.1314576566*h1_25 + -0.4689130187*h1_26 + 0.0751900077*h1_27 + 0.0552215874*h1_28 + 0.0912570581*h1_29 + -0.1978882253*h1_30 + -0.3326123655*h1_31)));
        h2_12 = (-0.1582134366 + 0.0704484433*h1_0 + -0.0678094476*h1_1 + 0.1799300462*h1_2 + -0.0964669362*h1_3 + 0.0699435994*h1_4 + -0.0488215871*h1_5 + 0.0198961440*h1_6 + 0.2526390553*h1_7 + 0.2758945227*h1_8 + -0.0469198413*h1_9 + 0.1577301323*h1_10 + 0.0737275034*h1_11 + -0.1129141971*h1_12 + 0.0886378661*h1_13 + -0.0864412189*h1_14 + -0.0505798385*h1_15 + 0.1421442330*h1_16 + -0.2466135919*h1_17 + 0.0737567469*h1_18 + 0.2736234963*h1_19 + 0.0644065365*h1_20 + -0.0349180959*h1_21 + -0.2451554537*h1_22 + -0.0285404567*h1_23 + 0.0653551221*h1_24 + 0.0296418872*h1_25 + -0.3112470210*h1_26 + 0.0537266880*h1_27 + -0.1348515451*h1_28 + 0.1117484570*h1_29 + -0.0914980695*h1_30 + -0.1385599971*h1_31 / `sqrt(1.0 + (-0.1582134366 + 0.0704484433*h1_0 + -0.0678094476*h1_1 + 0.1799300462*h1_2 + -0.0964669362*h1_3 + 0.0699435994*h1_4 + -0.0488215871*h1_5 + 0.0198961440*h1_6 + 0.2526390553*h1_7 + 0.2758945227*h1_8 + -0.0469198413*h1_9 + 0.1577301323*h1_10 + 0.0737275034*h1_11 + -0.1129141971*h1_12 + 0.0886378661*h1_13 + -0.0864412189*h1_14 + -0.0505798385*h1_15 + 0.1421442330*h1_16 + -0.2466135919*h1_17 + 0.0737567469*h1_18 + 0.2736234963*h1_19 + 0.0644065365*h1_20 + -0.0349180959*h1_21 + -0.2451554537*h1_22 + -0.0285404567*h1_23 + 0.0653551221*h1_24 + 0.0296418872*h1_25 + -0.3112470210*h1_26 + 0.0537266880*h1_27 + -0.1348515451*h1_28 + 0.1117484570*h1_29 + -0.0914980695*h1_30 + -0.1385599971*h1_31)*(-0.1582134366 + 0.0704484433*h1_0 + -0.0678094476*h1_1 + 0.1799300462*h1_2 + -0.0964669362*h1_3 + 0.0699435994*h1_4 + -0.0488215871*h1_5 + 0.0198961440*h1_6 + 0.2526390553*h1_7 + 0.2758945227*h1_8 + -0.0469198413*h1_9 + 0.1577301323*h1_10 + 0.0737275034*h1_11 + -0.1129141971*h1_12 + 0.0886378661*h1_13 + -0.0864412189*h1_14 + -0.0505798385*h1_15 + 0.1421442330*h1_16 + -0.2466135919*h1_17 + 0.0737567469*h1_18 + 0.2736234963*h1_19 + 0.0644065365*h1_20 + -0.0349180959*h1_21 + -0.2451554537*h1_22 + -0.0285404567*h1_23 + 0.0653551221*h1_24 + 0.0296418872*h1_25 + -0.3112470210*h1_26 + 0.0537266880*h1_27 + -0.1348515451*h1_28 + 0.1117484570*h1_29 + -0.0914980695*h1_30 + -0.1385599971*h1_31)));
        h2_13 = (-0.0350856744 + 0.1501308531*h1_0 + -0.1303453743*h1_1 + -0.0380610563*h1_2 + 0.2693675458*h1_3 + -0.1616858244*h1_4 + -0.0044426853*h1_5 + -0.0412193500*h1_6 + -0.0321568511*h1_7 + -0.0269504618*h1_8 + 0.0582655109*h1_9 + -0.1960431039*h1_10 + 0.0328114554*h1_11 + 0.1622252911*h1_12 + 0.0412983075*h1_13 + 0.0474460982*h1_14 + -0.0747574493*h1_15 + -0.0737250224*h1_16 + 0.1823607981*h1_17 + 0.0326816179*h1_18 + -0.1749673486*h1_19 + -0.0234225858*h1_20 + 0.0700110495*h1_21 + 0.0845470726*h1_22 + 0.2381379455*h1_23 + -0.2329218388*h1_24 + 0.0615748726*h1_25 + 0.3871167898*h1_26 + -0.1883896291*h1_27 + 0.0904964879*h1_28 + -0.1508333832*h1_29 + 0.0612264946*h1_30 + 0.1947472841*h1_31 / `sqrt(1.0 + (-0.0350856744 + 0.1501308531*h1_0 + -0.1303453743*h1_1 + -0.0380610563*h1_2 + 0.2693675458*h1_3 + -0.1616858244*h1_4 + -0.0044426853*h1_5 + -0.0412193500*h1_6 + -0.0321568511*h1_7 + -0.0269504618*h1_8 + 0.0582655109*h1_9 + -0.1960431039*h1_10 + 0.0328114554*h1_11 + 0.1622252911*h1_12 + 0.0412983075*h1_13 + 0.0474460982*h1_14 + -0.0747574493*h1_15 + -0.0737250224*h1_16 + 0.1823607981*h1_17 + 0.0326816179*h1_18 + -0.1749673486*h1_19 + -0.0234225858*h1_20 + 0.0700110495*h1_21 + 0.0845470726*h1_22 + 0.2381379455*h1_23 + -0.2329218388*h1_24 + 0.0615748726*h1_25 + 0.3871167898*h1_26 + -0.1883896291*h1_27 + 0.0904964879*h1_28 + -0.1508333832*h1_29 + 0.0612264946*h1_30 + 0.1947472841*h1_31)*(-0.0350856744 + 0.1501308531*h1_0 + -0.1303453743*h1_1 + -0.0380610563*h1_2 + 0.2693675458*h1_3 + -0.1616858244*h1_4 + -0.0044426853*h1_5 + -0.0412193500*h1_6 + -0.0321568511*h1_7 + -0.0269504618*h1_8 + 0.0582655109*h1_9 + -0.1960431039*h1_10 + 0.0328114554*h1_11 + 0.1622252911*h1_12 + 0.0412983075*h1_13 + 0.0474460982*h1_14 + -0.0747574493*h1_15 + -0.0737250224*h1_16 + 0.1823607981*h1_17 + 0.0326816179*h1_18 + -0.1749673486*h1_19 + -0.0234225858*h1_20 + 0.0700110495*h1_21 + 0.0845470726*h1_22 + 0.2381379455*h1_23 + -0.2329218388*h1_24 + 0.0615748726*h1_25 + 0.3871167898*h1_26 + -0.1883896291*h1_27 + 0.0904964879*h1_28 + -0.1508333832*h1_29 + 0.0612264946*h1_30 + 0.1947472841*h1_31)));
        h2_14 = (0.1389174610 + -0.1856144220*h1_0 + 0.0648047104*h1_1 + -0.0384036638*h1_2 + 0.0730302781*h1_3 + -0.2307588011*h1_4 + 0.0890400857*h1_5 + 0.1222498640*h1_6 + -0.1777597368*h1_7 + -0.2342590690*h1_8 + -0.1845369190*h1_9 + -0.1426432133*h1_10 + 0.1359456480*h1_11 + 0.2008859217*h1_12 + 0.0197746083*h1_13 + 0.1892425269*h1_14 + 0.1543625891*h1_15 + -0.1704076827*h1_16 + -0.0417252071*h1_17 + 0.0271189995*h1_18 + 0.0495589338*h1_19 + 0.0772032440*h1_20 + -0.0868107304*h1_21 + 0.2043323070*h1_22 + -0.0277733337*h1_23 + -0.0127521604*h1_24 + -0.0704261139*h1_25 + 0.2379931360*h1_26 + -0.2808947563*h1_27 + -0.0275672656*h1_28 + -0.0381015316*h1_29 + 0.2080402821*h1_30 + 0.0761506408*h1_31 / `sqrt(1.0 + (0.1389174610 + -0.1856144220*h1_0 + 0.0648047104*h1_1 + -0.0384036638*h1_2 + 0.0730302781*h1_3 + -0.2307588011*h1_4 + 0.0890400857*h1_5 + 0.1222498640*h1_6 + -0.1777597368*h1_7 + -0.2342590690*h1_8 + -0.1845369190*h1_9 + -0.1426432133*h1_10 + 0.1359456480*h1_11 + 0.2008859217*h1_12 + 0.0197746083*h1_13 + 0.1892425269*h1_14 + 0.1543625891*h1_15 + -0.1704076827*h1_16 + -0.0417252071*h1_17 + 0.0271189995*h1_18 + 0.0495589338*h1_19 + 0.0772032440*h1_20 + -0.0868107304*h1_21 + 0.2043323070*h1_22 + -0.0277733337*h1_23 + -0.0127521604*h1_24 + -0.0704261139*h1_25 + 0.2379931360*h1_26 + -0.2808947563*h1_27 + -0.0275672656*h1_28 + -0.0381015316*h1_29 + 0.2080402821*h1_30 + 0.0761506408*h1_31)*(0.1389174610 + -0.1856144220*h1_0 + 0.0648047104*h1_1 + -0.0384036638*h1_2 + 0.0730302781*h1_3 + -0.2307588011*h1_4 + 0.0890400857*h1_5 + 0.1222498640*h1_6 + -0.1777597368*h1_7 + -0.2342590690*h1_8 + -0.1845369190*h1_9 + -0.1426432133*h1_10 + 0.1359456480*h1_11 + 0.2008859217*h1_12 + 0.0197746083*h1_13 + 0.1892425269*h1_14 + 0.1543625891*h1_15 + -0.1704076827*h1_16 + -0.0417252071*h1_17 + 0.0271189995*h1_18 + 0.0495589338*h1_19 + 0.0772032440*h1_20 + -0.0868107304*h1_21 + 0.2043323070*h1_22 + -0.0277733337*h1_23 + -0.0127521604*h1_24 + -0.0704261139*h1_25 + 0.2379931360*h1_26 + -0.2808947563*h1_27 + -0.0275672656*h1_28 + -0.0381015316*h1_29 + 0.2080402821*h1_30 + 0.0761506408*h1_31)));
        h2_15 = (0.1214197576 + 0.1035262346*h1_0 + 0.0317543671*h1_1 + -0.1649483293*h1_2 + 0.0507973246*h1_3 + -0.2653399408*h1_4 + 0.1155193895*h1_5 + 0.1349966377*h1_6 + -0.1680900902*h1_7 + -0.3145566285*h1_8 + -0.1996595562*h1_9 + -0.1960776001*h1_10 + 0.0575500503*h1_11 + -0.2072547674*h1_12 + -0.0462367944*h1_13 + 0.0773710757*h1_14 + 0.1609812975*h1_15 + -0.0335688330*h1_16 + 0.2308528870*h1_17 + -0.1999405921*h1_18 + -0.1810451895*h1_19 + 0.0159369837*h1_20 + 0.1387529522*h1_21 + 0.2873114645*h1_22 + 0.1452903450*h1_23 + 0.0533952042*h1_24 + 0.0769757405*h1_25 + 0.3564988375*h1_26 + -0.1113463491*h1_27 + -0.0169637464*h1_28 + -0.0461730883*h1_29 + 0.0214230753*h1_30 + 0.2193525583*h1_31 / `sqrt(1.0 + (0.1214197576 + 0.1035262346*h1_0 + 0.0317543671*h1_1 + -0.1649483293*h1_2 + 0.0507973246*h1_3 + -0.2653399408*h1_4 + 0.1155193895*h1_5 + 0.1349966377*h1_6 + -0.1680900902*h1_7 + -0.3145566285*h1_8 + -0.1996595562*h1_9 + -0.1960776001*h1_10 + 0.0575500503*h1_11 + -0.2072547674*h1_12 + -0.0462367944*h1_13 + 0.0773710757*h1_14 + 0.1609812975*h1_15 + -0.0335688330*h1_16 + 0.2308528870*h1_17 + -0.1999405921*h1_18 + -0.1810451895*h1_19 + 0.0159369837*h1_20 + 0.1387529522*h1_21 + 0.2873114645*h1_22 + 0.1452903450*h1_23 + 0.0533952042*h1_24 + 0.0769757405*h1_25 + 0.3564988375*h1_26 + -0.1113463491*h1_27 + -0.0169637464*h1_28 + -0.0461730883*h1_29 + 0.0214230753*h1_30 + 0.2193525583*h1_31)*(0.1214197576 + 0.1035262346*h1_0 + 0.0317543671*h1_1 + -0.1649483293*h1_2 + 0.0507973246*h1_3 + -0.2653399408*h1_4 + 0.1155193895*h1_5 + 0.1349966377*h1_6 + -0.1680900902*h1_7 + -0.3145566285*h1_8 + -0.1996595562*h1_9 + -0.1960776001*h1_10 + 0.0575500503*h1_11 + -0.2072547674*h1_12 + -0.0462367944*h1_13 + 0.0773710757*h1_14 + 0.1609812975*h1_15 + -0.0335688330*h1_16 + 0.2308528870*h1_17 + -0.1999405921*h1_18 + -0.1810451895*h1_19 + 0.0159369837*h1_20 + 0.1387529522*h1_21 + 0.2873114645*h1_22 + 0.1452903450*h1_23 + 0.0533952042*h1_24 + 0.0769757405*h1_25 + 0.3564988375*h1_26 + -0.1113463491*h1_27 + -0.0169637464*h1_28 + -0.0461730883*h1_29 + 0.0214230753*h1_30 + 0.2193525583*h1_31)));
        h2_16 = (-0.2294626236 + -0.2826668322*h1_0 + -0.2423118651*h1_1 + -0.3455329835*h1_2 + -0.3354827166*h1_3 + 0.0169955101*h1_4 + 0.2561847866*h1_5 + 0.0556818955*h1_6 + -0.2482433617*h1_7 + -0.4185760021*h1_8 + 0.1618161350*h1_9 + -0.4099429846*h1_10 + -0.0676200688*h1_11 + 0.0343806744*h1_12 + -0.1387086064*h1_13 + 0.2373133004*h1_14 + -0.2902395129*h1_15 + 0.1720563620*h1_16 + -0.3162914813*h1_17 + 0.2915073931*h1_18 + 0.3276801705*h1_19 + 0.0366188996*h1_20 + -0.3118423820*h1_21 + -0.1188503951*h1_22 + -0.3120865524*h1_23 + 0.2430507094*h1_24 + -0.3551326096*h1_25 + 0.3768721223*h1_26 + 0.0502811745*h1_27 + -0.0919275582*h1_28 + 0.2783375084*h1_29 + -0.2234774828*h1_30 + 0.3291472495*h1_31 / `sqrt(1.0 + (-0.2294626236 + -0.2826668322*h1_0 + -0.2423118651*h1_1 + -0.3455329835*h1_2 + -0.3354827166*h1_3 + 0.0169955101*h1_4 + 0.2561847866*h1_5 + 0.0556818955*h1_6 + -0.2482433617*h1_7 + -0.4185760021*h1_8 + 0.1618161350*h1_9 + -0.4099429846*h1_10 + -0.0676200688*h1_11 + 0.0343806744*h1_12 + -0.1387086064*h1_13 + 0.2373133004*h1_14 + -0.2902395129*h1_15 + 0.1720563620*h1_16 + -0.3162914813*h1_17 + 0.2915073931*h1_18 + 0.3276801705*h1_19 + 0.0366188996*h1_20 + -0.3118423820*h1_21 + -0.1188503951*h1_22 + -0.3120865524*h1_23 + 0.2430507094*h1_24 + -0.3551326096*h1_25 + 0.3768721223*h1_26 + 0.0502811745*h1_27 + -0.0919275582*h1_28 + 0.2783375084*h1_29 + -0.2234774828*h1_30 + 0.3291472495*h1_31)*(-0.2294626236 + -0.2826668322*h1_0 + -0.2423118651*h1_1 + -0.3455329835*h1_2 + -0.3354827166*h1_3 + 0.0169955101*h1_4 + 0.2561847866*h1_5 + 0.0556818955*h1_6 + -0.2482433617*h1_7 + -0.4185760021*h1_8 + 0.1618161350*h1_9 + -0.4099429846*h1_10 + -0.0676200688*h1_11 + 0.0343806744*h1_12 + -0.1387086064*h1_13 + 0.2373133004*h1_14 + -0.2902395129*h1_15 + 0.1720563620*h1_16 + -0.3162914813*h1_17 + 0.2915073931*h1_18 + 0.3276801705*h1_19 + 0.0366188996*h1_20 + -0.3118423820*h1_21 + -0.1188503951*h1_22 + -0.3120865524*h1_23 + 0.2430507094*h1_24 + -0.3551326096*h1_25 + 0.3768721223*h1_26 + 0.0502811745*h1_27 + -0.0919275582*h1_28 + 0.2783375084*h1_29 + -0.2234774828*h1_30 + 0.3291472495*h1_31)));
        h2_17 = (0.1937903166 + 0.1715314537*h1_0 + 0.1985846609*h1_1 + -0.2216404229*h1_2 + 0.0864344910*h1_3 + -0.3030357659*h1_4 + 0.1260990351*h1_5 + -0.0179145429*h1_6 + -0.1022873372*h1_7 + -0.2230796963*h1_8 + -0.1389693916*h1_9 + -0.4078064859*h1_10 + 0.1026717722*h1_11 + -0.0674557090*h1_12 + 0.0718505308*h1_13 + 0.1066807136*h1_14 + 0.1206317768*h1_15 + -0.1529696137*h1_16 + 0.0609270595*h1_17 + -0.1584196985*h1_18 + -0.2262964398*h1_19 + 0.0446148440*h1_20 + -0.0198085103*h1_21 + 0.2111351937*h1_22 + 0.0616463460*h1_23 + 0.0510041974*h1_24 + 0.0343102291*h1_25 + 0.2265938371*h1_26 + 0.0739713088*h1_27 + 0.0669547841*h1_28 + -0.2224419564*h1_29 + 0.1136175692*h1_30 + 0.2097530216*h1_31 / `sqrt(1.0 + (0.1937903166 + 0.1715314537*h1_0 + 0.1985846609*h1_1 + -0.2216404229*h1_2 + 0.0864344910*h1_3 + -0.3030357659*h1_4 + 0.1260990351*h1_5 + -0.0179145429*h1_6 + -0.1022873372*h1_7 + -0.2230796963*h1_8 + -0.1389693916*h1_9 + -0.4078064859*h1_10 + 0.1026717722*h1_11 + -0.0674557090*h1_12 + 0.0718505308*h1_13 + 0.1066807136*h1_14 + 0.1206317768*h1_15 + -0.1529696137*h1_16 + 0.0609270595*h1_17 + -0.1584196985*h1_18 + -0.2262964398*h1_19 + 0.0446148440*h1_20 + -0.0198085103*h1_21 + 0.2111351937*h1_22 + 0.0616463460*h1_23 + 0.0510041974*h1_24 + 0.0343102291*h1_25 + 0.2265938371*h1_26 + 0.0739713088*h1_27 + 0.0669547841*h1_28 + -0.2224419564*h1_29 + 0.1136175692*h1_30 + 0.2097530216*h1_31)*(0.1937903166 + 0.1715314537*h1_0 + 0.1985846609*h1_1 + -0.2216404229*h1_2 + 0.0864344910*h1_3 + -0.3030357659*h1_4 + 0.1260990351*h1_5 + -0.0179145429*h1_6 + -0.1022873372*h1_7 + -0.2230796963*h1_8 + -0.1389693916*h1_9 + -0.4078064859*h1_10 + 0.1026717722*h1_11 + -0.0674557090*h1_12 + 0.0718505308*h1_13 + 0.1066807136*h1_14 + 0.1206317768*h1_15 + -0.1529696137*h1_16 + 0.0609270595*h1_17 + -0.1584196985*h1_18 + -0.2262964398*h1_19 + 0.0446148440*h1_20 + -0.0198085103*h1_21 + 0.2111351937*h1_22 + 0.0616463460*h1_23 + 0.0510041974*h1_24 + 0.0343102291*h1_25 + 0.2265938371*h1_26 + 0.0739713088*h1_27 + 0.0669547841*h1_28 + -0.2224419564*h1_29 + 0.1136175692*h1_30 + 0.2097530216*h1_31)));
        h2_18 = (0.0016977555 + 0.1815758198*h1_0 + -0.2127199024*h1_1 + 0.2261320502*h1_2 + 0.0267353617*h1_3 + 0.2677796483*h1_4 + -0.0950485691*h1_5 + -0.2283610553*h1_6 + 0.2260519415*h1_7 + 0.3488872051*h1_8 + -0.0440743230*h1_9 + 0.2004487365*h1_10 + 0.1275046915*h1_11 + 0.2684446871*h1_12 + 0.0625329912*h1_13 + -0.0500331111*h1_14 + -0.1866656989*h1_15 + 0.1104278043*h1_16 + -0.1623093486*h1_17 + 0.2108618617*h1_18 + 0.1398355067*h1_19 + -0.0691248327*h1_20 + -0.1086562499*h1_21 + -0.2691165805*h1_22 + -0.2867889106*h1_23 + 0.2341715991*h1_24 + -0.0521963127*h1_25 + -0.2278887033*h1_26 + 0.0492018163*h1_27 + -0.0005271147*h1_28 + 0.1066671833*h1_29 + 0.0849851072*h1_30 + -0.1533629596*h1_31 / `sqrt(1.0 + (0.0016977555 + 0.1815758198*h1_0 + -0.2127199024*h1_1 + 0.2261320502*h1_2 + 0.0267353617*h1_3 + 0.2677796483*h1_4 + -0.0950485691*h1_5 + -0.2283610553*h1_6 + 0.2260519415*h1_7 + 0.3488872051*h1_8 + -0.0440743230*h1_9 + 0.2004487365*h1_10 + 0.1275046915*h1_11 + 0.2684446871*h1_12 + 0.0625329912*h1_13 + -0.0500331111*h1_14 + -0.1866656989*h1_15 + 0.1104278043*h1_16 + -0.1623093486*h1_17 + 0.2108618617*h1_18 + 0.1398355067*h1_19 + -0.0691248327*h1_20 + -0.1086562499*h1_21 + -0.2691165805*h1_22 + -0.2867889106*h1_23 + 0.2341715991*h1_24 + -0.0521963127*h1_25 + -0.2278887033*h1_26 + 0.0492018163*h1_27 + -0.0005271147*h1_28 + 0.1066671833*h1_29 + 0.0849851072*h1_30 + -0.1533629596*h1_31)*(0.0016977555 + 0.1815758198*h1_0 + -0.2127199024*h1_1 + 0.2261320502*h1_2 + 0.0267353617*h1_3 + 0.2677796483*h1_4 + -0.0950485691*h1_5 + -0.2283610553*h1_6 + 0.2260519415*h1_7 + 0.3488872051*h1_8 + -0.0440743230*h1_9 + 0.2004487365*h1_10 + 0.1275046915*h1_11 + 0.2684446871*h1_12 + 0.0625329912*h1_13 + -0.0500331111*h1_14 + -0.1866656989*h1_15 + 0.1104278043*h1_16 + -0.1623093486*h1_17 + 0.2108618617*h1_18 + 0.1398355067*h1_19 + -0.0691248327*h1_20 + -0.1086562499*h1_21 + -0.2691165805*h1_22 + -0.2867889106*h1_23 + 0.2341715991*h1_24 + -0.0521963127*h1_25 + -0.2278887033*h1_26 + 0.0492018163*h1_27 + -0.0005271147*h1_28 + 0.1066671833*h1_29 + 0.0849851072*h1_30 + -0.1533629596*h1_31)));
        h2_19 = (-0.2507934272 + 0.1357469857*h1_0 + 0.0740932599*h1_1 + 0.1885076016*h1_2 + -0.2493310720*h1_3 + 0.0789836273*h1_4 + -0.2870632410*h1_5 + -0.2181501985*h1_6 + 0.0887667686*h1_7 + 0.2147919089*h1_8 + 0.1871547997*h1_9 + 0.2927583456*h1_10 + -0.1004597694*h1_11 + -0.0366506241*h1_12 + 0.1182687357*h1_13 + -0.1140334308*h1_14 + -0.0281142350*h1_15 + 0.0821986571*h1_16 + -0.1104390025*h1_17 + 0.1562706679*h1_18 + -0.0410873815*h1_19 + 0.2078273445*h1_20 + -0.0060203220*h1_21 + -0.2145614326*h1_22 + -0.1833590716*h1_23 + 0.0168984476*h1_24 + 0.0861264393*h1_25 + -0.3505239189*h1_26 + 0.2411352247*h1_27 + -0.1587293297*h1_28 + -0.0086940741*h1_29 + -0.1427283436*h1_30 + -0.0609264672*h1_31 / `sqrt(1.0 + (-0.2507934272 + 0.1357469857*h1_0 + 0.0740932599*h1_1 + 0.1885076016*h1_2 + -0.2493310720*h1_3 + 0.0789836273*h1_4 + -0.2870632410*h1_5 + -0.2181501985*h1_6 + 0.0887667686*h1_7 + 0.2147919089*h1_8 + 0.1871547997*h1_9 + 0.2927583456*h1_10 + -0.1004597694*h1_11 + -0.0366506241*h1_12 + 0.1182687357*h1_13 + -0.1140334308*h1_14 + -0.0281142350*h1_15 + 0.0821986571*h1_16 + -0.1104390025*h1_17 + 0.1562706679*h1_18 + -0.0410873815*h1_19 + 0.2078273445*h1_20 + -0.0060203220*h1_21 + -0.2145614326*h1_22 + -0.1833590716*h1_23 + 0.0168984476*h1_24 + 0.0861264393*h1_25 + -0.3505239189*h1_26 + 0.2411352247*h1_27 + -0.1587293297*h1_28 + -0.0086940741*h1_29 + -0.1427283436*h1_30 + -0.0609264672*h1_31)*(-0.2507934272 + 0.1357469857*h1_0 + 0.0740932599*h1_1 + 0.1885076016*h1_2 + -0.2493310720*h1_3 + 0.0789836273*h1_4 + -0.2870632410*h1_5 + -0.2181501985*h1_6 + 0.0887667686*h1_7 + 0.2147919089*h1_8 + 0.1871547997*h1_9 + 0.2927583456*h1_10 + -0.1004597694*h1_11 + -0.0366506241*h1_12 + 0.1182687357*h1_13 + -0.1140334308*h1_14 + -0.0281142350*h1_15 + 0.0821986571*h1_16 + -0.1104390025*h1_17 + 0.1562706679*h1_18 + -0.0410873815*h1_19 + 0.2078273445*h1_20 + -0.0060203220*h1_21 + -0.2145614326*h1_22 + -0.1833590716*h1_23 + 0.0168984476*h1_24 + 0.0861264393*h1_25 + -0.3505239189*h1_26 + 0.2411352247*h1_27 + -0.1587293297*h1_28 + -0.0086940741*h1_29 + -0.1427283436*h1_30 + -0.0609264672*h1_31)));
        h2_20 = (-0.0262012761 + 0.0041472083*h1_0 + 0.0494816750*h1_1 + -0.0034895958*h1_2 + -0.0485130362*h1_3 + -0.1528755426*h1_4 + -0.0954600200*h1_5 + 0.0040000905*h1_6 + -0.2391412109*h1_7 + -0.2027498037*h1_8 + -0.2616387606*h1_9 + -0.0152432285*h1_10 + 0.0154295741*h1_11 + 0.1634119451*h1_12 + -0.0636962131*h1_13 + 0.0433293320*h1_14 + 0.0853058845*h1_15 + 0.0878194645*h1_16 + -0.0205314718*h1_17 + 0.0050474312*h1_18 + -0.0342787839*h1_19 + 0.1829511821*h1_20 + 0.1690979898*h1_21 + 0.1792167127*h1_22 + 0.0647447407*h1_23 + -0.1646151096*h1_24 + 0.0079612695*h1_25 + 0.2642305493*h1_26 + -0.1292085201*h1_27 + 0.1124268472*h1_28 + -0.2270129621*h1_29 + 0.1843335181*h1_30 + 0.1471213996*h1_31 / `sqrt(1.0 + (-0.0262012761 + 0.0041472083*h1_0 + 0.0494816750*h1_1 + -0.0034895958*h1_2 + -0.0485130362*h1_3 + -0.1528755426*h1_4 + -0.0954600200*h1_5 + 0.0040000905*h1_6 + -0.2391412109*h1_7 + -0.2027498037*h1_8 + -0.2616387606*h1_9 + -0.0152432285*h1_10 + 0.0154295741*h1_11 + 0.1634119451*h1_12 + -0.0636962131*h1_13 + 0.0433293320*h1_14 + 0.0853058845*h1_15 + 0.0878194645*h1_16 + -0.0205314718*h1_17 + 0.0050474312*h1_18 + -0.0342787839*h1_19 + 0.1829511821*h1_20 + 0.1690979898*h1_21 + 0.1792167127*h1_22 + 0.0647447407*h1_23 + -0.1646151096*h1_24 + 0.0079612695*h1_25 + 0.2642305493*h1_26 + -0.1292085201*h1_27 + 0.1124268472*h1_28 + -0.2270129621*h1_29 + 0.1843335181*h1_30 + 0.1471213996*h1_31)*(-0.0262012761 + 0.0041472083*h1_0 + 0.0494816750*h1_1 + -0.0034895958*h1_2 + -0.0485130362*h1_3 + -0.1528755426*h1_4 + -0.0954600200*h1_5 + 0.0040000905*h1_6 + -0.2391412109*h1_7 + -0.2027498037*h1_8 + -0.2616387606*h1_9 + -0.0152432285*h1_10 + 0.0154295741*h1_11 + 0.1634119451*h1_12 + -0.0636962131*h1_13 + 0.0433293320*h1_14 + 0.0853058845*h1_15 + 0.0878194645*h1_16 + -0.0205314718*h1_17 + 0.0050474312*h1_18 + -0.0342787839*h1_19 + 0.1829511821*h1_20 + 0.1690979898*h1_21 + 0.1792167127*h1_22 + 0.0647447407*h1_23 + -0.1646151096*h1_24 + 0.0079612695*h1_25 + 0.2642305493*h1_26 + -0.1292085201*h1_27 + 0.1124268472*h1_28 + -0.2270129621*h1_29 + 0.1843335181*h1_30 + 0.1471213996*h1_31)));
        h2_21 = (-0.0256662816 + -0.3440983891*h1_0 + -0.1402279437*h1_1 + 0.0042532734*h1_2 + -0.1027628556*h1_3 + 0.0889931992*h1_4 + 0.0735478103*h1_5 + 0.1898302883*h1_6 + -0.0744688436*h1_7 + 0.0933825225*h1_8 + 0.0741907954*h1_9 + 0.2032806873*h1_10 + 0.1193846241*h1_11 + -0.1447539479*h1_12 + 0.1788523495*h1_13 + -0.0092466371*h1_14 + -0.2170246243*h1_15 + -0.1579828113*h1_16 + -0.0972841457*h1_17 + 0.1810565740*h1_18 + 0.1114344150*h1_19 + -0.0647448003*h1_20 + -0.0514336005*h1_21 + -0.1109324172*h1_22 + -0.3011324108*h1_23 + 0.0595856197*h1_24 + 0.0800091997*h1_25 + -0.3416172862*h1_26 + 0.0016800321*h1_27 + -0.2313482165*h1_28 + 0.2918588221*h1_29 + -0.2210589647*h1_30 + -0.0822045729*h1_31 / `sqrt(1.0 + (-0.0256662816 + -0.3440983891*h1_0 + -0.1402279437*h1_1 + 0.0042532734*h1_2 + -0.1027628556*h1_3 + 0.0889931992*h1_4 + 0.0735478103*h1_5 + 0.1898302883*h1_6 + -0.0744688436*h1_7 + 0.0933825225*h1_8 + 0.0741907954*h1_9 + 0.2032806873*h1_10 + 0.1193846241*h1_11 + -0.1447539479*h1_12 + 0.1788523495*h1_13 + -0.0092466371*h1_14 + -0.2170246243*h1_15 + -0.1579828113*h1_16 + -0.0972841457*h1_17 + 0.1810565740*h1_18 + 0.1114344150*h1_19 + -0.0647448003*h1_20 + -0.0514336005*h1_21 + -0.1109324172*h1_22 + -0.3011324108*h1_23 + 0.0595856197*h1_24 + 0.0800091997*h1_25 + -0.3416172862*h1_26 + 0.0016800321*h1_27 + -0.2313482165*h1_28 + 0.2918588221*h1_29 + -0.2210589647*h1_30 + -0.0822045729*h1_31)*(-0.0256662816 + -0.3440983891*h1_0 + -0.1402279437*h1_1 + 0.0042532734*h1_2 + -0.1027628556*h1_3 + 0.0889931992*h1_4 + 0.0735478103*h1_5 + 0.1898302883*h1_6 + -0.0744688436*h1_7 + 0.0933825225*h1_8 + 0.0741907954*h1_9 + 0.2032806873*h1_10 + 0.1193846241*h1_11 + -0.1447539479*h1_12 + 0.1788523495*h1_13 + -0.0092466371*h1_14 + -0.2170246243*h1_15 + -0.1579828113*h1_16 + -0.0972841457*h1_17 + 0.1810565740*h1_18 + 0.1114344150*h1_19 + -0.0647448003*h1_20 + -0.0514336005*h1_21 + -0.1109324172*h1_22 + -0.3011324108*h1_23 + 0.0595856197*h1_24 + 0.0800091997*h1_25 + -0.3416172862*h1_26 + 0.0016800321*h1_27 + -0.2313482165*h1_28 + 0.2918588221*h1_29 + -0.2210589647*h1_30 + -0.0822045729*h1_31)));
        h2_22 = (0.0574710779 + -0.0464090519*h1_0 + 0.1283220351*h1_1 + -0.1207502186*h1_2 + 0.0701609999*h1_3 + -0.2373773158*h1_4 + -0.0220342185*h1_5 + -0.1430599391*h1_6 + -0.1947523654*h1_7 + -0.0555664003*h1_8 + -0.2185539305*h1_9 + -0.1250219047*h1_10 + 0.2665622234*h1_11 + 0.1510679424*h1_12 + -0.1789595783*h1_13 + 0.0331499502*h1_14 + 0.0274602566*h1_15 + -0.1177832186*h1_16 + -0.0609559752*h1_17 + -0.2260852158*h1_18 + 0.0271169581*h1_19 + 0.1942825615*h1_20 + 0.1460869014*h1_21 + 0.1893522441*h1_22 + 0.0790624768*h1_23 + -0.0571377575*h1_24 + -0.1581024975*h1_25 + 0.2215819359*h1_26 + -0.0448141135*h1_27 + 0.0407306254*h1_28 + -0.1547518671*h1_29 + 0.0041325497*h1_30 + 0.1351474524*h1_31 / `sqrt(1.0 + (0.0574710779 + -0.0464090519*h1_0 + 0.1283220351*h1_1 + -0.1207502186*h1_2 + 0.0701609999*h1_3 + -0.2373773158*h1_4 + -0.0220342185*h1_5 + -0.1430599391*h1_6 + -0.1947523654*h1_7 + -0.0555664003*h1_8 + -0.2185539305*h1_9 + -0.1250219047*h1_10 + 0.2665622234*h1_11 + 0.1510679424*h1_12 + -0.1789595783*h1_13 + 0.0331499502*h1_14 + 0.0274602566*h1_15 + -0.1177832186*h1_16 + -0.0609559752*h1_17 + -0.2260852158*h1_18 + 0.0271169581*h1_19 + 0.1942825615*h1_20 + 0.1460869014*h1_21 + 0.1893522441*h1_22 + 0.0790624768*h1_23 + -0.0571377575*h1_24 + -0.1581024975*h1_25 + 0.2215819359*h1_26 + -0.0448141135*h1_27 + 0.0407306254*h1_28 + -0.1547518671*h1_29 + 0.0041325497*h1_30 + 0.1351474524*h1_31)*(0.0574710779 + -0.0464090519*h1_0 + 0.1283220351*h1_1 + -0.1207502186*h1_2 + 0.0701609999*h1_3 + -0.2373773158*h1_4 + -0.0220342185*h1_5 + -0.1430599391*h1_6 + -0.1947523654*h1_7 + -0.0555664003*h1_8 + -0.2185539305*h1_9 + -0.1250219047*h1_10 + 0.2665622234*h1_11 + 0.1510679424*h1_12 + -0.1789595783*h1_13 + 0.0331499502*h1_14 + 0.0274602566*h1_15 + -0.1177832186*h1_16 + -0.0609559752*h1_17 + -0.2260852158*h1_18 + 0.0271169581*h1_19 + 0.1942825615*h1_20 + 0.1460869014*h1_21 + 0.1893522441*h1_22 + 0.0790624768*h1_23 + -0.0571377575*h1_24 + -0.1581024975*h1_25 + 0.2215819359*h1_26 + -0.0448141135*h1_27 + 0.0407306254*h1_28 + -0.1547518671*h1_29 + 0.0041325497*h1_30 + 0.1351474524*h1_31)));
        h2_23 = (-0.0765302703 + 0.0243689958*h1_0 + -0.2033585757*h1_1 + 0.2008214742*h1_2 + -0.0963135362*h1_3 + 0.1707620770*h1_4 + 0.1020729393*h1_5 + 0.0347354785*h1_6 + 0.1349382102*h1_7 + 0.1174292862*h1_8 + -0.0303621776*h1_9 + 0.1440768987*h1_10 + 0.0196409095*h1_11 + 0.0513377413*h1_12 + -0.0682597458*h1_13 + 0.0788303167*h1_14 + -0.0023049617*h1_15 + -0.0158664100*h1_16 + -0.0418815650*h1_17 + 0.0573351160*h1_18 + 0.1625555605*h1_19 + 0.1406252235*h1_20 + -0.2794771791*h1_21 + -0.2237626761*h1_22 + -0.1549517512*h1_23 + 0.1047252938*h1_24 + -0.0802506134*h1_25 + -0.4746571481*h1_26 + 0.0736459941*h1_27 + -0.0816388205*h1_28 + 0.1504997462*h1_29 + -0.0442280807*h1_30 + -0.1505509019*h1_31 / `sqrt(1.0 + (-0.0765302703 + 0.0243689958*h1_0 + -0.2033585757*h1_1 + 0.2008214742*h1_2 + -0.0963135362*h1_3 + 0.1707620770*h1_4 + 0.1020729393*h1_5 + 0.0347354785*h1_6 + 0.1349382102*h1_7 + 0.1174292862*h1_8 + -0.0303621776*h1_9 + 0.1440768987*h1_10 + 0.0196409095*h1_11 + 0.0513377413*h1_12 + -0.0682597458*h1_13 + 0.0788303167*h1_14 + -0.0023049617*h1_15 + -0.0158664100*h1_16 + -0.0418815650*h1_17 + 0.0573351160*h1_18 + 0.1625555605*h1_19 + 0.1406252235*h1_20 + -0.2794771791*h1_21 + -0.2237626761*h1_22 + -0.1549517512*h1_23 + 0.1047252938*h1_24 + -0.0802506134*h1_25 + -0.4746571481*h1_26 + 0.0736459941*h1_27 + -0.0816388205*h1_28 + 0.1504997462*h1_29 + -0.0442280807*h1_30 + -0.1505509019*h1_31)*(-0.0765302703 + 0.0243689958*h1_0 + -0.2033585757*h1_1 + 0.2008214742*h1_2 + -0.0963135362*h1_3 + 0.1707620770*h1_4 + 0.1020729393*h1_5 + 0.0347354785*h1_6 + 0.1349382102*h1_7 + 0.1174292862*h1_8 + -0.0303621776*h1_9 + 0.1440768987*h1_10 + 0.0196409095*h1_11 + 0.0513377413*h1_12 + -0.0682597458*h1_13 + 0.0788303167*h1_14 + -0.0023049617*h1_15 + -0.0158664100*h1_16 + -0.0418815650*h1_17 + 0.0573351160*h1_18 + 0.1625555605*h1_19 + 0.1406252235*h1_20 + -0.2794771791*h1_21 + -0.2237626761*h1_22 + -0.1549517512*h1_23 + 0.1047252938*h1_24 + -0.0802506134*h1_25 + -0.4746571481*h1_26 + 0.0736459941*h1_27 + -0.0816388205*h1_28 + 0.1504997462*h1_29 + -0.0442280807*h1_30 + -0.1505509019*h1_31)));
        h2_24 = (0.0821386725 + 0.0544746555*h1_0 + 0.1422418207*h1_1 + -0.0988008603*h1_2 + 0.1845168173*h1_3 + -0.1191378161*h1_4 + -0.0922588110*h1_5 + -0.0367161818*h1_6 + -0.0880574137*h1_7 + -0.2215648741*h1_8 + -0.0446609780*h1_9 + -0.0217450783*h1_10 + 0.1251888871*h1_11 + 0.0454221927*h1_12 + -0.0251301974*h1_13 + -0.0802507028*h1_14 + -0.0923586041*h1_15 + 0.0785059482*h1_16 + -0.1415482163*h1_17 + -0.2569486201*h1_18 + -0.1661103815*h1_19 + 0.0589417964*h1_20 + 0.1160934865*h1_21 + 0.0467663407*h1_22 + 0.1447140276*h1_23 + -0.1783189327*h1_24 + 0.0221467558*h1_25 + 0.3289046884*h1_26 + -0.0731124207*h1_27 + 0.0725206956*h1_28 + -0.0181309339*h1_29 + -0.0356745608*h1_30 + 0.1523969769*h1_31 / `sqrt(1.0 + (0.0821386725 + 0.0544746555*h1_0 + 0.1422418207*h1_1 + -0.0988008603*h1_2 + 0.1845168173*h1_3 + -0.1191378161*h1_4 + -0.0922588110*h1_5 + -0.0367161818*h1_6 + -0.0880574137*h1_7 + -0.2215648741*h1_8 + -0.0446609780*h1_9 + -0.0217450783*h1_10 + 0.1251888871*h1_11 + 0.0454221927*h1_12 + -0.0251301974*h1_13 + -0.0802507028*h1_14 + -0.0923586041*h1_15 + 0.0785059482*h1_16 + -0.1415482163*h1_17 + -0.2569486201*h1_18 + -0.1661103815*h1_19 + 0.0589417964*h1_20 + 0.1160934865*h1_21 + 0.0467663407*h1_22 + 0.1447140276*h1_23 + -0.1783189327*h1_24 + 0.0221467558*h1_25 + 0.3289046884*h1_26 + -0.0731124207*h1_27 + 0.0725206956*h1_28 + -0.0181309339*h1_29 + -0.0356745608*h1_30 + 0.1523969769*h1_31)*(0.0821386725 + 0.0544746555*h1_0 + 0.1422418207*h1_1 + -0.0988008603*h1_2 + 0.1845168173*h1_3 + -0.1191378161*h1_4 + -0.0922588110*h1_5 + -0.0367161818*h1_6 + -0.0880574137*h1_7 + -0.2215648741*h1_8 + -0.0446609780*h1_9 + -0.0217450783*h1_10 + 0.1251888871*h1_11 + 0.0454221927*h1_12 + -0.0251301974*h1_13 + -0.0802507028*h1_14 + -0.0923586041*h1_15 + 0.0785059482*h1_16 + -0.1415482163*h1_17 + -0.2569486201*h1_18 + -0.1661103815*h1_19 + 0.0589417964*h1_20 + 0.1160934865*h1_21 + 0.0467663407*h1_22 + 0.1447140276*h1_23 + -0.1783189327*h1_24 + 0.0221467558*h1_25 + 0.3289046884*h1_26 + -0.0731124207*h1_27 + 0.0725206956*h1_28 + -0.0181309339*h1_29 + -0.0356745608*h1_30 + 0.1523969769*h1_31)));
        h2_25 = (0.1388356835 + -0.1052766964*h1_0 + 0.2245898545*h1_1 + -0.2607607245*h1_2 + 0.1640790105*h1_3 + -0.3337686062*h1_4 + 0.1594746709*h1_5 + 0.0940361470*h1_6 + 0.0512336120*h1_7 + -0.2446989268*h1_8 + 0.0227538794*h1_9 + -0.2576000988*h1_10 + -0.0082559334*h1_11 + 0.1022464186*h1_12 + -0.0473186597*h1_13 + -0.0280017126*h1_14 + -0.0910757780*h1_15 + -0.1190758720*h1_16 + 0.0771924853*h1_17 + 0.0596459918*h1_18 + 0.0419891216*h1_19 + 0.0513742939*h1_20 + -0.0622233562*h1_21 + -0.0467492156*h1_22 + 0.2755972147*h1_23 + -0.2007374913*h1_24 + -0.1257338375*h1_25 + 0.0847227424*h1_26 + -0.2330975831*h1_27 + 0.0798682943*h1_28 + -0.1588370800*h1_29 + 0.0990316346*h1_30 + 0.1201935560*h1_31 / `sqrt(1.0 + (0.1388356835 + -0.1052766964*h1_0 + 0.2245898545*h1_1 + -0.2607607245*h1_2 + 0.1640790105*h1_3 + -0.3337686062*h1_4 + 0.1594746709*h1_5 + 0.0940361470*h1_6 + 0.0512336120*h1_7 + -0.2446989268*h1_8 + 0.0227538794*h1_9 + -0.2576000988*h1_10 + -0.0082559334*h1_11 + 0.1022464186*h1_12 + -0.0473186597*h1_13 + -0.0280017126*h1_14 + -0.0910757780*h1_15 + -0.1190758720*h1_16 + 0.0771924853*h1_17 + 0.0596459918*h1_18 + 0.0419891216*h1_19 + 0.0513742939*h1_20 + -0.0622233562*h1_21 + -0.0467492156*h1_22 + 0.2755972147*h1_23 + -0.2007374913*h1_24 + -0.1257338375*h1_25 + 0.0847227424*h1_26 + -0.2330975831*h1_27 + 0.0798682943*h1_28 + -0.1588370800*h1_29 + 0.0990316346*h1_30 + 0.1201935560*h1_31)*(0.1388356835 + -0.1052766964*h1_0 + 0.2245898545*h1_1 + -0.2607607245*h1_2 + 0.1640790105*h1_3 + -0.3337686062*h1_4 + 0.1594746709*h1_5 + 0.0940361470*h1_6 + 0.0512336120*h1_7 + -0.2446989268*h1_8 + 0.0227538794*h1_9 + -0.2576000988*h1_10 + -0.0082559334*h1_11 + 0.1022464186*h1_12 + -0.0473186597*h1_13 + -0.0280017126*h1_14 + -0.0910757780*h1_15 + -0.1190758720*h1_16 + 0.0771924853*h1_17 + 0.0596459918*h1_18 + 0.0419891216*h1_19 + 0.0513742939*h1_20 + -0.0622233562*h1_21 + -0.0467492156*h1_22 + 0.2755972147*h1_23 + -0.2007374913*h1_24 + -0.1257338375*h1_25 + 0.0847227424*h1_26 + -0.2330975831*h1_27 + 0.0798682943*h1_28 + -0.1588370800*h1_29 + 0.0990316346*h1_30 + 0.1201935560*h1_31)));
        h2_26 = (0.0174450316 + 0.0801823512*h1_0 + 0.0065278029*h1_1 + -0.1168645844*h1_2 + 0.1927744299*h1_3 + -0.0635240525*h1_4 + 0.2236292064*h1_5 + 0.0472745188*h1_6 + -0.2548120916*h1_7 + -0.2001083642*h1_8 + -0.0930213854*h1_9 + -0.1218532696*h1_10 + 0.1478780806*h1_11 + 0.0229865648*h1_12 + -0.1074079573*h1_13 + 0.1225217804*h1_14 + 0.2145174444*h1_15 + -0.1132647023*h1_16 + -0.0055192695*h1_17 + -0.1216413528*h1_18 + -0.2668063939*h1_19 + -0.1652029902*h1_20 + 0.2469653338*h1_21 + 0.0609107427*h1_22 + 0.2477599084*h1_23 + -0.2212037593*h1_24 + 0.0969360992*h1_25 + 0.4052780271*h1_26 + 0.0223186240*h1_27 + 0.0516878963*h1_28 + -0.1019491404*h1_29 + -0.0394695289*h1_30 + 0.0774075910*h1_31 / `sqrt(1.0 + (0.0174450316 + 0.0801823512*h1_0 + 0.0065278029*h1_1 + -0.1168645844*h1_2 + 0.1927744299*h1_3 + -0.0635240525*h1_4 + 0.2236292064*h1_5 + 0.0472745188*h1_6 + -0.2548120916*h1_7 + -0.2001083642*h1_8 + -0.0930213854*h1_9 + -0.1218532696*h1_10 + 0.1478780806*h1_11 + 0.0229865648*h1_12 + -0.1074079573*h1_13 + 0.1225217804*h1_14 + 0.2145174444*h1_15 + -0.1132647023*h1_16 + -0.0055192695*h1_17 + -0.1216413528*h1_18 + -0.2668063939*h1_19 + -0.1652029902*h1_20 + 0.2469653338*h1_21 + 0.0609107427*h1_22 + 0.2477599084*h1_23 + -0.2212037593*h1_24 + 0.0969360992*h1_25 + 0.4052780271*h1_26 + 0.0223186240*h1_27 + 0.0516878963*h1_28 + -0.1019491404*h1_29 + -0.0394695289*h1_30 + 0.0774075910*h1_31)*(0.0174450316 + 0.0801823512*h1_0 + 0.0065278029*h1_1 + -0.1168645844*h1_2 + 0.1927744299*h1_3 + -0.0635240525*h1_4 + 0.2236292064*h1_5 + 0.0472745188*h1_6 + -0.2548120916*h1_7 + -0.2001083642*h1_8 + -0.0930213854*h1_9 + -0.1218532696*h1_10 + 0.1478780806*h1_11 + 0.0229865648*h1_12 + -0.1074079573*h1_13 + 0.1225217804*h1_14 + 0.2145174444*h1_15 + -0.1132647023*h1_16 + -0.0055192695*h1_17 + -0.1216413528*h1_18 + -0.2668063939*h1_19 + -0.1652029902*h1_20 + 0.2469653338*h1_21 + 0.0609107427*h1_22 + 0.2477599084*h1_23 + -0.2212037593*h1_24 + 0.0969360992*h1_25 + 0.4052780271*h1_26 + 0.0223186240*h1_27 + 0.0516878963*h1_28 + -0.1019491404*h1_29 + -0.0394695289*h1_30 + 0.0774075910*h1_31)));
        h2_27 = (0.0803414509 + -0.1027816162*h1_0 + 0.1435297877*h1_1 + -0.2696523964*h1_2 + 0.0812608823*h1_3 + -0.4172685742*h1_4 + 0.1551187485*h1_5 + 0.0113461455*h1_6 + -0.1574357152*h1_7 + -0.1809854954*h1_8 + -0.1987187415*h1_9 + -0.3044789433*h1_10 + -0.1496401280*h1_11 + 0.0383704826*h1_12 + -0.2019872516*h1_13 + 0.1191130430*h1_14 + 0.1551705450*h1_15 + -0.1627586037*h1_16 + 0.1979249120*h1_17 + 0.0492762215*h1_18 + -0.1704131365*h1_19 + 0.0156941582*h1_20 + 0.1458228976*h1_21 + 0.2438570708*h1_22 + 0.2619259953*h1_23 + -0.1778158247*h1_24 + -0.1621109396*h1_25 + 0.2524260283*h1_26 + -0.1270590127*h1_27 + -0.0217461344*h1_28 + -0.1407947838*h1_29 + 0.1285675168*h1_30 + 0.1923320591*h1_31 / `sqrt(1.0 + (0.0803414509 + -0.1027816162*h1_0 + 0.1435297877*h1_1 + -0.2696523964*h1_2 + 0.0812608823*h1_3 + -0.4172685742*h1_4 + 0.1551187485*h1_5 + 0.0113461455*h1_6 + -0.1574357152*h1_7 + -0.1809854954*h1_8 + -0.1987187415*h1_9 + -0.3044789433*h1_10 + -0.1496401280*h1_11 + 0.0383704826*h1_12 + -0.2019872516*h1_13 + 0.1191130430*h1_14 + 0.1551705450*h1_15 + -0.1627586037*h1_16 + 0.1979249120*h1_17 + 0.0492762215*h1_18 + -0.1704131365*h1_19 + 0.0156941582*h1_20 + 0.1458228976*h1_21 + 0.2438570708*h1_22 + 0.2619259953*h1_23 + -0.1778158247*h1_24 + -0.1621109396*h1_25 + 0.2524260283*h1_26 + -0.1270590127*h1_27 + -0.0217461344*h1_28 + -0.1407947838*h1_29 + 0.1285675168*h1_30 + 0.1923320591*h1_31)*(0.0803414509 + -0.1027816162*h1_0 + 0.1435297877*h1_1 + -0.2696523964*h1_2 + 0.0812608823*h1_3 + -0.4172685742*h1_4 + 0.1551187485*h1_5 + 0.0113461455*h1_6 + -0.1574357152*h1_7 + -0.1809854954*h1_8 + -0.1987187415*h1_9 + -0.3044789433*h1_10 + -0.1496401280*h1_11 + 0.0383704826*h1_12 + -0.2019872516*h1_13 + 0.1191130430*h1_14 + 0.1551705450*h1_15 + -0.1627586037*h1_16 + 0.1979249120*h1_17 + 0.0492762215*h1_18 + -0.1704131365*h1_19 + 0.0156941582*h1_20 + 0.1458228976*h1_21 + 0.2438570708*h1_22 + 0.2619259953*h1_23 + -0.1778158247*h1_24 + -0.1621109396*h1_25 + 0.2524260283*h1_26 + -0.1270590127*h1_27 + -0.0217461344*h1_28 + -0.1407947838*h1_29 + 0.1285675168*h1_30 + 0.1923320591*h1_31)));
        h2_28 = (-0.1614098996 + -0.1423434466*h1_0 + -0.1876470894*h1_1 + -0.0362343341*h1_2 + 0.0699910447*h1_3 + 0.2140032202*h1_4 + -0.1694560796*h1_5 + -0.1717357934*h1_6 + 0.0140097402*h1_7 + 0.1489325911*h1_8 + 0.1435636133*h1_9 + 0.3688563406*h1_10 + 0.0984911919*h1_11 + 0.0511894859*h1_12 + -0.0841005594*h1_13 + -0.2186033875*h1_14 + 0.0847921148*h1_15 + -0.0449958704*h1_16 + -0.0623243265*h1_17 + 0.0991106406*h1_18 + 0.2580334246*h1_19 + 0.1510056555*h1_20 + -0.1476231515*h1_21 + -0.2709641755*h1_22 + -0.1110590026*h1_23 + -0.0521485992*h1_24 + 0.0639151856*h1_25 + -0.2981091142*h1_26 + 0.1699492186*h1_27 + -0.0842403919*h1_28 + -0.0161665566*h1_29 + -0.2065351903*h1_30 + -0.3049417138*h1_31 / `sqrt(1.0 + (-0.1614098996 + -0.1423434466*h1_0 + -0.1876470894*h1_1 + -0.0362343341*h1_2 + 0.0699910447*h1_3 + 0.2140032202*h1_4 + -0.1694560796*h1_5 + -0.1717357934*h1_6 + 0.0140097402*h1_7 + 0.1489325911*h1_8 + 0.1435636133*h1_9 + 0.3688563406*h1_10 + 0.0984911919*h1_11 + 0.0511894859*h1_12 + -0.0841005594*h1_13 + -0.2186033875*h1_14 + 0.0847921148*h1_15 + -0.0449958704*h1_16 + -0.0623243265*h1_17 + 0.0991106406*h1_18 + 0.2580334246*h1_19 + 0.1510056555*h1_20 + -0.1476231515*h1_21 + -0.2709641755*h1_22 + -0.1110590026*h1_23 + -0.0521485992*h1_24 + 0.0639151856*h1_25 + -0.2981091142*h1_26 + 0.1699492186*h1_27 + -0.0842403919*h1_28 + -0.0161665566*h1_29 + -0.2065351903*h1_30 + -0.3049417138*h1_31)*(-0.1614098996 + -0.1423434466*h1_0 + -0.1876470894*h1_1 + -0.0362343341*h1_2 + 0.0699910447*h1_3 + 0.2140032202*h1_4 + -0.1694560796*h1_5 + -0.1717357934*h1_6 + 0.0140097402*h1_7 + 0.1489325911*h1_8 + 0.1435636133*h1_9 + 0.3688563406*h1_10 + 0.0984911919*h1_11 + 0.0511894859*h1_12 + -0.0841005594*h1_13 + -0.2186033875*h1_14 + 0.0847921148*h1_15 + -0.0449958704*h1_16 + -0.0623243265*h1_17 + 0.0991106406*h1_18 + 0.2580334246*h1_19 + 0.1510056555*h1_20 + -0.1476231515*h1_21 + -0.2709641755*h1_22 + -0.1110590026*h1_23 + -0.0521485992*h1_24 + 0.0639151856*h1_25 + -0.2981091142*h1_26 + 0.1699492186*h1_27 + -0.0842403919*h1_28 + -0.0161665566*h1_29 + -0.2065351903*h1_30 + -0.3049417138*h1_31)));
        h2_29 = (0.0508354716 + 0.0385083333*h1_0 + -0.0439554453*h1_1 + -0.1320232451*h1_2 + 0.0529883839*h1_3 + -0.3140348196*h1_4 + 0.2534444928*h1_5 + 0.1851398796*h1_6 + 0.0071518417*h1_7 + -0.0782251805*h1_8 + -0.2012188584*h1_9 + -0.4011133015*h1_10 + -0.0850709304*h1_11 + 0.0671639070*h1_12 + 0.0916099101*h1_13 + 0.2664068043*h1_14 + -0.0059482274*h1_15 + -0.1713039428*h1_16 + 0.2905085385*h1_17 + -0.2897063494*h1_18 + -0.2437590659*h1_19 + 0.0519585162*h1_20 + -0.0258551873*h1_21 + 0.1110285893*h1_22 + 0.2480545938*h1_23 + 0.0548016354*h1_24 + -0.0985226706*h1_25 + 0.2710930109*h1_26 + -0.0072150459*h1_27 + 0.1959073842*h1_28 + -0.2652116418*h1_29 + 0.0675317422*h1_30 + 0.1148509085*h1_31 / `sqrt(1.0 + (0.0508354716 + 0.0385083333*h1_0 + -0.0439554453*h1_1 + -0.1320232451*h1_2 + 0.0529883839*h1_3 + -0.3140348196*h1_4 + 0.2534444928*h1_5 + 0.1851398796*h1_6 + 0.0071518417*h1_7 + -0.0782251805*h1_8 + -0.2012188584*h1_9 + -0.4011133015*h1_10 + -0.0850709304*h1_11 + 0.0671639070*h1_12 + 0.0916099101*h1_13 + 0.2664068043*h1_14 + -0.0059482274*h1_15 + -0.1713039428*h1_16 + 0.2905085385*h1_17 + -0.2897063494*h1_18 + -0.2437590659*h1_19 + 0.0519585162*h1_20 + -0.0258551873*h1_21 + 0.1110285893*h1_22 + 0.2480545938*h1_23 + 0.0548016354*h1_24 + -0.0985226706*h1_25 + 0.2710930109*h1_26 + -0.0072150459*h1_27 + 0.1959073842*h1_28 + -0.2652116418*h1_29 + 0.0675317422*h1_30 + 0.1148509085*h1_31)*(0.0508354716 + 0.0385083333*h1_0 + -0.0439554453*h1_1 + -0.1320232451*h1_2 + 0.0529883839*h1_3 + -0.3140348196*h1_4 + 0.2534444928*h1_5 + 0.1851398796*h1_6 + 0.0071518417*h1_7 + -0.0782251805*h1_8 + -0.2012188584*h1_9 + -0.4011133015*h1_10 + -0.0850709304*h1_11 + 0.0671639070*h1_12 + 0.0916099101*h1_13 + 0.2664068043*h1_14 + -0.0059482274*h1_15 + -0.1713039428*h1_16 + 0.2905085385*h1_17 + -0.2897063494*h1_18 + -0.2437590659*h1_19 + 0.0519585162*h1_20 + -0.0258551873*h1_21 + 0.1110285893*h1_22 + 0.2480545938*h1_23 + 0.0548016354*h1_24 + -0.0985226706*h1_25 + 0.2710930109*h1_26 + -0.0072150459*h1_27 + 0.1959073842*h1_28 + -0.2652116418*h1_29 + 0.0675317422*h1_30 + 0.1148509085*h1_31)));
        h2_30 = (-0.2516717613 + -0.0988151208*h1_0 + 0.0019014986*h1_1 + 0.1252411902*h1_2 + -0.0875963941*h1_3 + 0.1315218657*h1_4 + -0.2040224522*h1_5 + -0.1010923386*h1_6 + 0.1321522146*h1_7 + 0.1816793382*h1_8 + 0.0004227062*h1_9 + 0.4677493274*h1_10 + -0.1769562215*h1_11 + -0.1041428223*h1_12 + 0.1710231602*h1_13 + -0.1617359519*h1_14 + -0.0242185574*h1_15 + 0.0345749520*h1_16 + -0.1462380737*h1_17 + 0.0921318084*h1_18 + 0.2881921232*h1_19 + 0.1504842937*h1_20 + -0.1331071705*h1_21 + -0.1865965873*h1_22 + -0.2616662085*h1_23 + 0.0088069560*h1_24 + 0.0279610250*h1_25 + -0.3449910581*h1_26 + 0.0972745344*h1_27 + 0.0712194070*h1_28 + 0.1871704608*h1_29 + -0.0709748715*h1_30 + -0.2132932246*h1_31 / `sqrt(1.0 + (-0.2516717613 + -0.0988151208*h1_0 + 0.0019014986*h1_1 + 0.1252411902*h1_2 + -0.0875963941*h1_3 + 0.1315218657*h1_4 + -0.2040224522*h1_5 + -0.1010923386*h1_6 + 0.1321522146*h1_7 + 0.1816793382*h1_8 + 0.0004227062*h1_9 + 0.4677493274*h1_10 + -0.1769562215*h1_11 + -0.1041428223*h1_12 + 0.1710231602*h1_13 + -0.1617359519*h1_14 + -0.0242185574*h1_15 + 0.0345749520*h1_16 + -0.1462380737*h1_17 + 0.0921318084*h1_18 + 0.2881921232*h1_19 + 0.1504842937*h1_20 + -0.1331071705*h1_21 + -0.1865965873*h1_22 + -0.2616662085*h1_23 + 0.0088069560*h1_24 + 0.0279610250*h1_25 + -0.3449910581*h1_26 + 0.0972745344*h1_27 + 0.0712194070*h1_28 + 0.1871704608*h1_29 + -0.0709748715*h1_30 + -0.2132932246*h1_31)*(-0.2516717613 + -0.0988151208*h1_0 + 0.0019014986*h1_1 + 0.1252411902*h1_2 + -0.0875963941*h1_3 + 0.1315218657*h1_4 + -0.2040224522*h1_5 + -0.1010923386*h1_6 + 0.1321522146*h1_7 + 0.1816793382*h1_8 + 0.0004227062*h1_9 + 0.4677493274*h1_10 + -0.1769562215*h1_11 + -0.1041428223*h1_12 + 0.1710231602*h1_13 + -0.1617359519*h1_14 + -0.0242185574*h1_15 + 0.0345749520*h1_16 + -0.1462380737*h1_17 + 0.0921318084*h1_18 + 0.2881921232*h1_19 + 0.1504842937*h1_20 + -0.1331071705*h1_21 + -0.1865965873*h1_22 + -0.2616662085*h1_23 + 0.0088069560*h1_24 + 0.0279610250*h1_25 + -0.3449910581*h1_26 + 0.0972745344*h1_27 + 0.0712194070*h1_28 + 0.1871704608*h1_29 + -0.0709748715*h1_30 + -0.2132932246*h1_31)));
        h2_31 = (-0.0816196650 + 0.0843799338*h1_0 + -0.2291855067*h1_1 + 0.1280206591*h1_2 + -0.0608034469*h1_3 + 0.2129832506*h1_4 + -0.0275580566*h1_5 + -0.0754557997*h1_6 + 0.0693086162*h1_7 + 0.0897057950*h1_8 + -0.1062227115*h1_9 + 0.3511337042*h1_10 + 0.0494524688*h1_11 + -0.0812120810*h1_12 + 0.0548834242*h1_13 + -0.1815801263*h1_14 + 0.0389808863*h1_15 + 0.0509869829*h1_16 + 0.0262512043*h1_17 + 0.2617722154*h1_18 + 0.2132689059*h1_19 + 0.1494001001*h1_20 + -0.0614056699*h1_21 + -0.0857519358*h1_22 + -0.2995067835*h1_23 + 0.0476793200*h1_24 + 0.0513140373*h1_25 + -0.2788128555*h1_26 + 0.0335319377*h1_27 + 0.0599622689*h1_28 + 0.2423466593*h1_29 + 0.0013654254*h1_30 + -0.0710392818*h1_31 / `sqrt(1.0 + (-0.0816196650 + 0.0843799338*h1_0 + -0.2291855067*h1_1 + 0.1280206591*h1_2 + -0.0608034469*h1_3 + 0.2129832506*h1_4 + -0.0275580566*h1_5 + -0.0754557997*h1_6 + 0.0693086162*h1_7 + 0.0897057950*h1_8 + -0.1062227115*h1_9 + 0.3511337042*h1_10 + 0.0494524688*h1_11 + -0.0812120810*h1_12 + 0.0548834242*h1_13 + -0.1815801263*h1_14 + 0.0389808863*h1_15 + 0.0509869829*h1_16 + 0.0262512043*h1_17 + 0.2617722154*h1_18 + 0.2132689059*h1_19 + 0.1494001001*h1_20 + -0.0614056699*h1_21 + -0.0857519358*h1_22 + -0.2995067835*h1_23 + 0.0476793200*h1_24 + 0.0513140373*h1_25 + -0.2788128555*h1_26 + 0.0335319377*h1_27 + 0.0599622689*h1_28 + 0.2423466593*h1_29 + 0.0013654254*h1_30 + -0.0710392818*h1_31)*(-0.0816196650 + 0.0843799338*h1_0 + -0.2291855067*h1_1 + 0.1280206591*h1_2 + -0.0608034469*h1_3 + 0.2129832506*h1_4 + -0.0275580566*h1_5 + -0.0754557997*h1_6 + 0.0693086162*h1_7 + 0.0897057950*h1_8 + -0.1062227115*h1_9 + 0.3511337042*h1_10 + 0.0494524688*h1_11 + -0.0812120810*h1_12 + 0.0548834242*h1_13 + -0.1815801263*h1_14 + 0.0389808863*h1_15 + 0.0509869829*h1_16 + 0.0262512043*h1_17 + 0.2617722154*h1_18 + 0.2132689059*h1_19 + 0.1494001001*h1_20 + -0.0614056699*h1_21 + -0.0857519358*h1_22 + -0.2995067835*h1_23 + 0.0476793200*h1_24 + 0.0513140373*h1_25 + -0.2788128555*h1_26 + 0.0335319377*h1_27 + 0.0599622689*h1_28 + 0.2423466593*h1_29 + 0.0013654254*h1_30 + -0.0710392818*h1_31)));

    // Step 4: Output Layer (linear)
        log10_Id_nn = -2.0663378239 + 0.5408739448*h2_0 + -0.4010577500*h2_1 + 0.2179212719*h2_2 + 0.3643452227*h2_3 + 0.6553559899*h2_4 + -0.3904200494*h2_5 + -0.5570498705*h2_6 + -0.1034303829*h2_7 + 0.4115221798*h2_8 + -0.7348614335*h2_9 + -0.6130856276*h2_10 + 0.4505774975*h2_11 + 0.7014290094*h2_12 + -0.4691249132*h2_13 + -0.5419127345*h2_14 + -0.5014021993*h2_15 + 0.0926208124*h2_16 + -0.5366588831*h2_17 + 0.6711933613*h2_18 + 0.6859835982*h2_19 + -0.4067977071*h2_20 + 0.2580865622*h2_21 + -0.3776700199*h2_22 + 0.4439840019*h2_23 + -0.4455296397*h2_24 + -0.5056904554*h2_25 + -0.5954387188*h2_26 + -0.4079929590*h2_27 + 0.6285961866*h2_28 + -0.5805450678*h2_29 + 0.6054655910*h2_30 + 0.6405922771*h2_31;

    // ==============================================
    // Output Calculation
    // ==============================================
    // Clamp output to reasonable range
    log10_Id = (log10_Id_nn < -12) ? -12 : ((log10_Id_nn > -3) ? -3 : log10_Id_nn);

    // Convert from log10 to linear current
    Ids = pow(10, log10_Id);

    // Apply geometry scaling
    Ids = Ids * (W / 10e-6);

    // ==============================================
    // Physical Constraints
    // ==============================================
    if (Ids < 1e-12) Ids = 1e-12;
    if (Ids > 1e-3) Ids = 1e-3;
    if (VDS == 0) Ids = 0;

    // Gate and body currents (negligible for DC)
    Igs = 0;
    Ibs = 0;

    // ==============================================
    // Transconductance (for AC analysis)
    // ==============================================
    gm = ddx(Ids, VGS);
    gds = ddx(Ids, VDS);

    // ==============================================
    // Analog Behavior Block
    // ==============================================
    analog begin
        // Read terminal voltages
        VGS = V(g, s);
        VDS = V(d, s);
        VBS = V(b, s);

        // Calculate drain current (from NN above)

        // Assign currents to terminals
        I(d, s) <+ Ids;
        I(g, s) <+ Igs;
        I(b, s) <+ Ibs;
    end

endmodule

// ============================================================
// End of BSIM-NN Verilog-A Model
// ============================================================
